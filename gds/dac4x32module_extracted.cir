* Extracted by KLayout with SG13G2 LVS runset on : 24/03/2026 21:14

.SUBCKT dac4x32module VSS EN[0]|EN[7]|INP|ON ENB[0]|ENB[7]|INN|ONB
+ INP|ON|ON[0]|ON[63] INN|ONB|ONB[0]|ONB[63] INP|ON|ON[1]|ON[62]
+ INN|ONB|ONB[1]|ONB[62] INP|ON|ON[2]|ON[61] INN|ONB|ONB[2]|ONB[61]
+ INP|ON|ON[3]|ON[60] INN|ONB|ONB[3]|ONB[60] INP|ON|ON[4]|ON[59]
+ INN|ONB|ONB[4]|ONB[59] INP|ON|ON[58]|ON[5] INN|ONB|ONB[58]|ONB[5]
+ INP|ON|ON[57]|ON[6] INN|ONB|ONB[57]|ONB[6] INP|ON|ON[56]|ON[7]
+ INN|ONB|ONB[56]|ONB[7] INP|ON|ON[55]|ON[8] INN|ONB|ONB[55]|ONB[8]
+ INP|ON|ON[54]|ON[9] INN|ONB|ONB[54]|ONB[9] INP|ON|ON[10]|ON[53]
+ INN|ONB|ONB[10]|ONB[53] INP|ON|ON[11]|ON[52] INN|ONB|ONB[11]|ONB[52]
+ INP|ON|ON[12]|ON[51] INN|ONB|ONB[12]|ONB[51] INP|ON|ON[13]|ON[50]
+ INN|ONB|ONB[13]|ONB[50] INP|ON|ON[14]|ON[49] INN|ONB|ONB[14]|ONB[49]
+ INP|ON|ON[15]|ON[48] INN|ONB|ONB[15]|ONB[48] EN[1]|EN[6]|INP|ON
+ ENB[1]|ENB[6]|INN|ONB EN[0]|EN[5]|INP|ON ENB[0]|ENB[5]|INN|ONB
+ INP|ON|ON[0]|ON[47] INN|ONB|ONB[0]|ONB[47] INP|ON|ON[1]|ON[46]
+ INN|ONB|ONB[1]|ONB[46] INP|ON|ON[2]|ON[45] INN|ONB|ONB[2]|ONB[45]
+ INP|ON|ON[3]|ON[44] INN|ONB|ONB[3]|ONB[44] INP|ON|ON[43]|ON[4]
+ INN|ONB|ONB[43]|ONB[4] INP|ON|ON[42]|ON[5] INN|ONB|ONB[42]|ONB[5]
+ INP|ON|ON[41]|ON[6] INN|ONB|ONB[41]|ONB[6] INP|ON|ON[40]|ON[7]
+ INN|ONB|ONB[40]|ONB[7] INP|ON|ON[39]|ON[8] INN|ONB|ONB[39]|ONB[8]
+ INP|ON|ON[38]|ON[9] INN|ONB|ONB[38]|ONB[9] INP|ON|ON[10]|ON[37]
+ INN|ONB|ONB[10]|ONB[37] INP|ON|ON[11]|ON[36] INN|ONB|ONB[11]|ONB[36]
+ INP|ON|ON[12]|ON[35] INN|ONB|ONB[12]|ONB[35] INP|ON|ON[13]|ON[34]
+ INN|ONB|ONB[13]|ONB[34] INP|ON|ON[14]|ON[33] INN|ONB|ONB[14]|ONB[33]
+ INP|ON|ON[15]|ON[32] INN|ONB|ONB[15]|ONB[32] EN[1]|EN[4]|INP|ON
+ ENB[1]|ENB[4]|INN|ONB EN[0]|EN[3]|INP|ON ENB[0]|ENB[3]|INN|ONB
+ INP|ON|ON[0]|ON[31] INN|ONB|ONB[0]|ONB[31] INP|ON|ON[1]|ON[30]
+ INN|ONB|ONB[1]|ONB[30] INP|ON|ON[29]|ON[2] INN|ONB|ONB[29]|ONB[2]
+ INP|ON|ON[28]|ON[3] INN|ONB|ONB[28]|ONB[3] INP|ON|ON[27]|ON[4]
+ INN|ONB|ONB[27]|ONB[4] INP|ON|ON[26]|ON[5] INN|ONB|ONB[26]|ONB[5]
+ INP|ON|ON[25]|ON[6] INN|ONB|ONB[25]|ONB[6] INP|ON|ON[24]|ON[7]
+ INN|ONB|ONB[24]|ONB[7] INP|ON|ON[23]|ON[8] INN|ONB|ONB[23]|ONB[8]
+ INP|ON|ON[22]|ON[9] INN|ONB|ONB[22]|ONB[9] INP|ON|ON[10]|ON[21]
+ INN|ONB|ONB[10]|ONB[21] INP|ON|ON[11]|ON[20] INN|ONB|ONB[11]|ONB[20]
+ INP|ON|ON[12]|ON[19] INN|ONB|ONB[12]|ONB[19] INP|ON|ON[13]|ON[18]
+ INN|ONB|ONB[13]|ONB[18] INP|ON|ON[14]|ON[17] INN|ONB|ONB[14]|ONB[17]
+ INP|ON|ON[15]|ON[16] INN|ONB|ONB[15]|ONB[16] EN[1]|EN[2]|INP|ON
+ ENB[1]|ENB[2]|INN|ONB EN[0]|EN[1]|INP|ON ENB[0]|ENB[1]|INN|ONB
+ INP|ON|ON[0]|ON[15] INN|ONB|ONB[0]|ONB[15] INP|ON|ON[14]|ON[1]
+ INN|ONB|ONB[14]|ONB[1] INP|ON|ON[13]|ON[2] INN|ONB|ONB[13]|ONB[2]
+ INP|ON|ON[12]|ON[3] INN|ONB|ONB[12]|ONB[3] INP|ON|ON[11]|ON[4]
+ INN|ONB|ONB[11]|ONB[4] INP|ON|ON[10]|ON[5] INN|ONB|ONB[10]|ONB[5]
+ INP|ON|ON[6]|ON[9] INN|ONB|ONB[6]|ONB[9] INP|ON|ON[7]|ON[8]
+ INN|ONB|ONB[7]|ONB[8] INP|ON|ON[7]|ON[8]$1 INN|ONB|ONB[7]|ONB[8]$1
+ INP|ON|ON[6]|ON[9]$1 INN|ONB|ONB[6]|ONB[9]$1 INP|ON|ON[10]|ON[5]$1
+ INN|ONB|ONB[10]|ONB[5]$1 INP|ON|ON[11]|ON[4]$1 INN|ONB|ONB[11]|ONB[4]$1
+ INP|ON|ON[12]|ON[3]$1 INN|ONB|ONB[12]|ONB[3]$1 INP|ON|ON[13]|ON[2]$1
+ INN|ONB|ONB[13]|ONB[2]$1 INP|ON|ON[14]|ON[1]$1 INN|ONB|ONB[14]|ONB[1]$1
+ INP|ON|ON[0]|ON[15]$1 INN|ONB|ONB[0]|ONB[15]$1 EN[0]|EN[1]|INP|ON$1
+ ENB[0]|ENB[1]|INN|ONB$1 OUTN OUTP OUTN$1 OUTP$1 OUTN$2 OUTP$2 OUTN$3 OUTP$3
+ OUTN$4 VDD OUTP$4 OUTN$5 OUTP$5 OUTN$6 OUTP$6 OUTN$7 OUTP$7 OUTN$8 OUTP$8
+ OUTN$9 OUTP$9 OUTN$10 OUTP$10 OUTN$11 OUTP$11 OUTN$12 OUTP$12 OUTN$13 OUTP$13
+ OUTN$14 OUTP$14 OUTN$15 OUTP$15 OUTN$16 OUTP$16 OUTN$17 OUTP$17 OUTN$18
+ OUTP$18 OUTN$19 OUTP$19 OUTN$20 OUTP$20 OUTN$21 OUTP$21 OUTN$22 OUTP$22
+ OUTN$23 OUTP$23 OUTN$24 OUTP$24 OUTN$25 OUTP$25 OUTN$26 OUTP$26 OUTN$27
+ OUTP$27 OUTN$28 OUTP$28 OUTN$29 OUTP$29 OUTN$30 OUTP$30 OUTN$31 OUTP$31
+ OUTN$32 OUTP$32 OUTN$33 OUTP$33 OUTN$34 OUTP$34 OUTN$35 OUTP$35 OUTN$36
+ OUTP$36 OUTN$37 OUTP$37 OUTN$38 OUTP$38 OUTN$39 OUTP$39 OUTN$40 OUTP$40
+ OUTN$41 OUTP$41 OUTN$42 OUTP$42 OUTN$43 OUTP$43 OUTN$44 OUTP$44 OUTN$45
+ OUTP$45 OUTN$46 OUTP$46 OUTN$47 OUTP$47 OUTN$48 OUTP$48 OUTN$49 OUTP$49
+ OUTN$50 OUTP$50 OUTN$51 OUTP$51 OUTN$52 OUTP$52 OUTN$53 OUTP$53 OUTN$54
+ OUTP$54 OUTN$55 OUTP$55 OUTN$56 OUTP$56 OUTN$57 OUTP$57 OUTN$58 OUTP$58
+ OUTN$59 OUTP$59 OUTN$60 OUTP$60 OUTN$61 OUTP$61 OUTN$62 OUTP$62 OUTN$63
+ OUTP$63 OUTN$64 OUTP$64 OUTN$65 OUTP$65 OUTN$66 OUTP$66 OUTN$67 OUTP$67
+ OUTN$68 OUTP$68 OUTN$69 OUTP$69 OUTN$70 OUTP$70 OUTN$71 OUTP$71
+ C10|VbiasP[3]|VcascP|VcascP[0] C10|C30|VbiasP[2]|VcascP|VcascP[0]
+ C10|C30|VbiasP[1]|VcascP|VcascP[0] C10|C30|VbiasP[0]|VcascP|VcascP[0]
+ VcascodeP VcascodeP$1 VcascodeP$2 VcascodeP$3 VcascodeP$4 VcascodeP$5
+ VcascodeP$6 VcascodeP$7 VcascodeP$8 VcascodeP$9 VcascodeP$10 VcascodeP$11
+ VcascodeP$12 VcascodeP$13 VcascodeP$14 VcascodeP$15 VcascodeP$16 VcascodeP$17
+ VcascodeP$18 VcascodeP$19 VcascodeP$20 VcascodeP$21 VcascodeP$22 VcascodeP$23
+ VcascodeP$24 VcascodeP$25 VcascodeP$26 VcascodeP$27 VcascodeP$28 VcascodeP$29
+ VcascodeP$30 VcascodeP$31 VcascodeP$32 VcascodeP$33 VcascodeP$34 VcascodeP$35
+ VcascodeP$36 VcascodeP$37 VcascodeP$38 VcascodeP$39 VcascodeP$40 VcascodeP$41
+ VcascodeP$42 VcascodeP$43 VcascodeP$44 VcascodeP$45 VcascodeP$46 VcascodeP$47
+ VcascodeP$48 VcascodeP$49 VcascodeP$50 VcascodeP$51 VcascodeP$52 VcascodeP$53
+ VcascodeP$54 VcascodeP$55 VcascodeP$56 VcascodeP$57 VcascodeP$58 VcascodeP$59
+ VcascodeP$60 VcascodeP$61 VcascodeP$62 VcascodeP$63 VcascodeP$64 VcascodeP$65
+ VcascodeP$66 VcascodeP$67 VcascodeP$68 VcascodeP$69 VcascodeP$70 VcascodeP$71
+ C11|Iout|VbiasP|VbiasP[0] C11|C31|Iout|VbiasP|VbiasP[0]
+ C11|C31|Iout|VbiasP|VbiasP[0]$1 C11|C31|Iout|VbiasP|VbiasP[0]$2 Iout
+ C01|Iout|VbiasP|VbiasP[1] C01|C21|Iout|VbiasP|VbiasP[1]
+ C01|C21|Iout|VbiasP|VbiasP[1]$1 C01|C21|Iout|VbiasP|VbiasP[1]$2
+ C00|VbiasP[4]|VcascP|VcascP[1] C00|C20|VbiasP[5]|VcascP|VcascP[1]
+ C00|C20|VbiasP[6]|VcascP|VcascP[1] C00|C20|VbiasP[7]|VcascP|VcascP[1]
+ VcascodeP$72 VcascodeP$73 VcascodeP$74 VcascodeP$75 VcascodeP$76 VcascodeP$77
+ VcascodeP$78 VcascodeP$79 VcascodeP$80 VcascodeP$81 VcascodeP$82 VcascodeP$83
+ VcascodeP$84 VcascodeP$85 VcascodeP$86 VcascodeP$87 VcascodeP$88 VcascodeP$89
+ VcascodeP$90 VcascodeP$91 VcascodeP$92 VcascodeP$93 VcascodeP$94 VcascodeP$95
+ VcascodeP$96 VcascodeP$97 VcascodeP$98 VcascodeP$99 VcascodeP$100
+ VcascodeP$101 VcascodeP$102 VcascodeP$103 VcascodeP$104 VcascodeP$105
+ VcascodeP$106 VcascodeP$107 VcascodeP$108 VcascodeP$109 VcascodeP$110
+ VcascodeP$111 VcascodeP$112 VcascodeP$113 VcascodeP$114 VcascodeP$115
+ VcascodeP$116 VcascodeP$117 VcascodeP$118 VcascodeP$119 VcascodeP$120
+ VcascodeP$121 VcascodeP$122 VcascodeP$123 VcascodeP$124 VcascodeP$125
+ VcascodeP$126 VcascodeP$127 VcascodeP$128 VcascodeP$129 VcascodeP$130
+ VcascodeP$131 VcascodeP$132 VcascodeP$133 VcascodeP$134 VcascodeP$135
+ VcascodeP$136 VcascodeP$137 VcascodeP$138 VcascodeP$139 VcascodeP$140
+ VcascodeP$141 VcascodeP$142 VcascodeP$143 OUTP$72 OUTN$72 OUTP$73 OUTN$73
+ OUTP$74 OUTN$74 OUTP$75 OUTN$75 OUTP$76 OUTN$76 OUTP$77 OUTN$77 OUTP$78
+ OUTN$78 OUTP$79 OUTN$79 OUTP$80 OUTN$80 OUTP$81 OUTN$81 OUTP$82 OUTN$82
+ OUTP$83 OUTN$83 OUTP$84 OUTN$84 OUTP$85 OUTN$85 OUTP$86 OUTN$86 OUTP$87
+ OUTN$87 OUTP$88 OUTN$88 OUTP$89 OUTN$89 OUTP$90 OUTN$90 OUTP$91 OUTN$91
+ OUTP$92 OUTN$92 OUTP$93 OUTN$93 OUTP$94 OUTN$94 OUTP$95 OUTN$95 OUTP$96
+ OUTN$96 OUTP$97 OUTN$97 OUTP$98 OUTN$98 OUTP$99 OUTN$99 OUTP$100 OUTN$100
+ OUTP$101 OUTN$101 OUTP$102 OUTN$102 OUTP$103 OUTN$103 OUTP$104 OUTN$104
+ OUTP$105 OUTN$105 OUTP$106 OUTN$106 OUTP$107 OUTN$107 OUTP$108 OUTN$108
+ OUTP$109 OUTN$109 OUTP$110 OUTN$110 OUTP$111 OUTN$111 OUTP$112 OUTN$112
+ OUTP$113 OUTN$113 OUTP$114 OUTN$114 OUTP$115 OUTN$115 OUTP$116 OUTN$116
+ OUTP$117 OUTN$117 OUTP$118 OUTN$118 OUTP$119 OUTN$119 OUTP$120 OUTN$120
+ OUTP$121 OUTN$121 OUTP$122 OUTN$122 OUTP$123 OUTN$123 OUTP$124 OUTN$124
+ OUTP$125 OUTN$125 OUTP$126 OUTN$126 OUTP$127 OUTN$127 OUTP$128 OUTN$128
+ OUTP$129 OUTN$129 OUTP$130 OUTN$130 OUTP$131 OUTN$131 OUTP$132 OUTN$132
+ OUTP$133 OUTN$133 OUTP$134 OUTN$134 OUTP$135 OUTN$135 OUTP$136 OUTN$136
+ OUTP$137 OUTN$137 OUTP$138 OUTN$138 OUTP$139 OUTN$139 OUTP$140 OUTN$140
+ OUTP$141 OUTN$141 OUTP$142 OUTN$142 OUTP$143 OUTN$143
+ ENB[1]|ENB[3]|ENB[8]|INN|ONB EN[1]|EN[3]|EN[8]|INP|ON
+ INN|ONB|ONB[15]|ONB[31]|ONB[64] INP|ON|ON[15]|ON[31]|ON[64]
+ INN|ONB|ONB[14]|ONB[30]|ONB[65] INP|ON|ON[14]|ON[30]|ON[65]
+ INN|ONB|ONB[13]|ONB[29]|ONB[66] INP|ON|ON[13]|ON[29]|ON[66]
+ INN|ONB|ONB[12]|ONB[28]|ONB[67] INP|ON|ON[12]|ON[28]|ON[67]
+ INN|ONB|ONB[11]|ONB[27]|ONB[68] INP|ON|ON[11]|ON[27]|ON[68]
+ INN|ONB|ONB[10]|ONB[26]|ONB[69] INP|ON|ON[10]|ON[26]|ON[69]
+ INN|ONB|ONB[25]|ONB[70]|ONB[9] INP|ON|ON[25]|ON[70]|ON[9]
+ INN|ONB|ONB[24]|ONB[71]|ONB[8] INP|ON|ON[24]|ON[71]|ON[8]
+ INN|ONB|ONB[23]|ONB[72]|ONB[7] INP|ON|ON[23]|ON[72]|ON[7]
+ INN|ONB|ONB[22]|ONB[6]|ONB[73] INP|ON|ON[22]|ON[6]|ON[73]
+ INN|ONB|ONB[21]|ONB[5]|ONB[74] INP|ON|ON[21]|ON[5]|ON[74]
+ INN|ONB|ONB[20]|ONB[4]|ONB[75] INP|ON|ON[20]|ON[4]|ON[75]
+ INN|ONB|ONB[19]|ONB[3]|ONB[76] INP|ON|ON[19]|ON[3]|ON[76]
+ INN|ONB|ONB[18]|ONB[2]|ONB[77] INP|ON|ON[18]|ON[2]|ON[77]
+ INN|ONB|ONB[17]|ONB[1]|ONB[78] INP|ON|ON[17]|ON[1]|ON[78]
+ INN|ONB|ONB[0]|ONB[16]|ONB[79] INP|ON|ON[0]|ON[16]|ON[79]
+ ENB[0]|ENB[2]|ENB[9]|INN|ONB EN[0]|EN[2]|EN[9]|INP|ON
+ ENB[10]|ENB[1]|ENB[3]|INN|ONB EN[10]|EN[1]|EN[3]|INP|ON
+ INN|ONB|ONB[15]|ONB[31]|ONB[80] INP|ON|ON[15]|ON[31]|ON[80]
+ INN|ONB|ONB[14]|ONB[30]|ONB[81] INP|ON|ON[14]|ON[30]|ON[81]
+ INN|ONB|ONB[13]|ONB[29]|ONB[82] INP|ON|ON[13]|ON[29]|ON[82]
+ INN|ONB|ONB[12]|ONB[28]|ONB[83] INP|ON|ON[12]|ON[28]|ON[83]
+ INN|ONB|ONB[11]|ONB[27]|ONB[84] INP|ON|ON[11]|ON[27]|ON[84]
+ INN|ONB|ONB[10]|ONB[26]|ONB[85] INP|ON|ON[10]|ON[26]|ON[85]
+ INN|ONB|ONB[25]|ONB[86]|ONB[9] INP|ON|ON[25]|ON[86]|ON[9]
+ INN|ONB|ONB[24]|ONB[87]|ONB[8] INP|ON|ON[24]|ON[87]|ON[8]
+ INN|ONB|ONB[23]|ONB[7]|ONB[88] INP|ON|ON[23]|ON[7]|ON[88]
+ INN|ONB|ONB[22]|ONB[6]|ONB[89] INP|ON|ON[22]|ON[6]|ON[89]
+ INN|ONB|ONB[21]|ONB[5]|ONB[90] INP|ON|ON[21]|ON[5]|ON[90]
+ INN|ONB|ONB[20]|ONB[4]|ONB[91] INP|ON|ON[20]|ON[4]|ON[91]
+ INN|ONB|ONB[19]|ONB[3]|ONB[92] INP|ON|ON[19]|ON[3]|ON[92]
+ INN|ONB|ONB[18]|ONB[2]|ONB[93] INP|ON|ON[18]|ON[2]|ON[93]
+ INN|ONB|ONB[17]|ONB[1]|ONB[94] INP|ON|ON[17]|ON[1]|ON[94]
+ INN|ONB|ONB[0]|ONB[16]|ONB[95] INP|ON|ON[0]|ON[16]|ON[95]
+ ENB[0]|ENB[11]|ENB[2]|INN|ONB EN[0]|EN[11]|EN[2]|INP|ON
+ ENB[12]|ENB[1]|ENB[3]|INN|ONB EN[12]|EN[1]|EN[3]|INP|ON
+ INN|ONB|ONB[15]|ONB[31]|ONB[96] INP|ON|ON[15]|ON[31]|ON[96]
+ INN|ONB|ONB[14]|ONB[30]|ONB[97] INP|ON|ON[14]|ON[30]|ON[97]
+ INN|ONB|ONB[13]|ONB[29]|ONB[98] INP|ON|ON[13]|ON[29]|ON[98]
+ INN|ONB|ONB[12]|ONB[28]|ONB[99] INP|ON|ON[12]|ON[28]|ON[99]
+ INN|ONB|ONB[100]|ONB[11]|ONB[27] INP|ON|ON[100]|ON[11]|ON[27]
+ INN|ONB|ONB[101]|ONB[10]|ONB[26] INP|ON|ON[101]|ON[10]|ON[26]
+ INN|ONB|ONB[102]|ONB[25]|ONB[9] INP|ON|ON[102]|ON[25]|ON[9]
+ INN|ONB|ONB[103]|ONB[24]|ONB[8] INP|ON|ON[103]|ON[24]|ON[8]
+ INN|ONB|ONB[104]|ONB[23]|ONB[7] INP|ON|ON[104]|ON[23]|ON[7]
+ INN|ONB|ONB[105]|ONB[22]|ONB[6] INP|ON|ON[105]|ON[22]|ON[6]
+ INN|ONB|ONB[106]|ONB[21]|ONB[5] INP|ON|ON[106]|ON[21]|ON[5]
+ INN|ONB|ONB[107]|ONB[20]|ONB[4] INP|ON|ON[107]|ON[20]|ON[4]
+ INN|ONB|ONB[108]|ONB[19]|ONB[3] INP|ON|ON[108]|ON[19]|ON[3]
+ INN|ONB|ONB[109]|ONB[18]|ONB[2] INP|ON|ON[109]|ON[18]|ON[2]
+ INN|ONB|ONB[110]|ONB[17]|ONB[1] INP|ON|ON[110]|ON[17]|ON[1]
+ INN|ONB|ONB[0]|ONB[111]|ONB[16] INP|ON|ON[0]|ON[111]|ON[16]
+ ENB[0]|ENB[13]|ENB[2]|INN|ONB EN[0]|EN[13]|EN[2]|INP|ON
+ ENB[14]|ENB[1]|ENB[3]|INN|ONB EN[14]|EN[1]|EN[3]|INP|ON
+ INN|ONB|ONB[112]|ONB[15]|ONB[31] INP|ON|ON[112]|ON[15]|ON[31]
+ INN|ONB|ONB[113]|ONB[14]|ONB[30] INP|ON|ON[113]|ON[14]|ON[30]
+ INN|ONB|ONB[114]|ONB[13]|ONB[29] INP|ON|ON[114]|ON[13]|ON[29]
+ INN|ONB|ONB[115]|ONB[12]|ONB[28] INP|ON|ON[115]|ON[12]|ON[28]
+ INN|ONB|ONB[116]|ONB[11]|ONB[27] INP|ON|ON[116]|ON[11]|ON[27]
+ INN|ONB|ONB[10]|ONB[117]|ONB[26] INP|ON|ON[10]|ON[117]|ON[26]
+ INN|ONB|ONB[118]|ONB[25]|ONB[9] INP|ON|ON[118]|ON[25]|ON[9]
+ INN|ONB|ONB[119]|ONB[24]|ONB[8] INP|ON|ON[119]|ON[24]|ON[8]
+ INN|ONB|ONB[120]|ONB[23]|ONB[7] INP|ON|ON[120]|ON[23]|ON[7]
+ INN|ONB|ONB[121]|ONB[22]|ONB[6] INP|ON|ON[121]|ON[22]|ON[6]
+ INN|ONB|ONB[122]|ONB[21]|ONB[5] INP|ON|ON[122]|ON[21]|ON[5]
+ INN|ONB|ONB[123]|ONB[20]|ONB[4] INP|ON|ON[123]|ON[20]|ON[4]
+ INN|ONB|ONB[124]|ONB[19]|ONB[3] INP|ON|ON[124]|ON[19]|ON[3]
+ INN|ONB|ONB[125]|ONB[18]|ONB[2] INP|ON|ON[125]|ON[18]|ON[2]
+ INN|ONB|ONB[126]|ONB[17]|ONB[1] INP|ON|ON[126]|ON[17]|ON[1]
+ INN|ONB|ONB[0]|ONB[127]|ONB[16] INP|ON|ON[0]|ON[127]|ON[16]
+ ENB[0]|ENB[15]|ENB[2]|INN|ONB EN[0]|EN[15]|EN[2]|INP|ON
M$1 OUTP$72 OUTN$72 VSS VSS sg13_lv_nmos L=0.52u W=0.15u AS=0.162p AD=0.0855p
+ PS=2.16u PD=1.14u
M$2 VSS OUTP$72 OUTN$72 VSS sg13_lv_nmos L=0.52u W=0.15u AS=0.0855p AD=0.162p
+ PS=1.14u PD=2.16u
M$3 OUTN OUTP VSS VSS sg13_lv_nmos L=0.52u W=0.15u AS=0.162p AD=0.0855p
+ PS=2.16u PD=1.14u
M$4 VSS OUTN OUTP VSS sg13_lv_nmos L=0.52u W=0.15u AS=0.0855p AD=0.162p
+ PS=1.14u PD=2.16u
M$5 OUTN$1 OUTP$1 VSS VSS sg13_lv_nmos L=0.52u W=0.15u AS=0.162p AD=0.0855p
+ PS=2.16u PD=1.14u
M$6 VSS OUTN$1 OUTP$1 VSS sg13_lv_nmos L=0.52u W=0.15u AS=0.0855p AD=0.162p
+ PS=1.14u PD=2.16u
M$7 OUTP$73 OUTN$73 VSS VSS sg13_lv_nmos L=0.52u W=0.15u AS=0.162p AD=0.0855p
+ PS=2.16u PD=1.14u
M$8 VSS OUTP$73 OUTN$73 VSS sg13_lv_nmos L=0.52u W=0.15u AS=0.0855p AD=0.162p
+ PS=1.14u PD=2.16u
M$9 OUTP$74 OUTN$74 VSS VSS sg13_lv_nmos L=0.52u W=0.15u AS=0.162p AD=0.0855p
+ PS=2.16u PD=1.14u
M$10 VSS OUTP$74 OUTN$74 VSS sg13_lv_nmos L=0.52u W=0.15u AS=0.0855p AD=0.162p
+ PS=1.14u PD=2.16u
M$11 OUTN$2 OUTP$2 VSS VSS sg13_lv_nmos L=0.52u W=0.15u AS=0.162p AD=0.0855p
+ PS=2.16u PD=1.14u
M$12 VSS OUTN$2 OUTP$2 VSS sg13_lv_nmos L=0.52u W=0.15u AS=0.0855p AD=0.162p
+ PS=1.14u PD=2.16u
M$13 OUTN$3 OUTP$3 VSS VSS sg13_lv_nmos L=0.52u W=0.15u AS=0.162p AD=0.0855p
+ PS=2.16u PD=1.14u
M$14 VSS OUTN$3 OUTP$3 VSS sg13_lv_nmos L=0.52u W=0.15u AS=0.0855p AD=0.162p
+ PS=1.14u PD=2.16u
M$15 OUTP$75 OUTN$75 VSS VSS sg13_lv_nmos L=0.52u W=0.15u AS=0.162p AD=0.0855p
+ PS=2.16u PD=1.14u
M$16 VSS OUTP$75 OUTN$75 VSS sg13_lv_nmos L=0.52u W=0.15u AS=0.0855p AD=0.162p
+ PS=1.14u PD=2.16u
M$17 OUTN$4 OUTP$4 VSS VSS sg13_lv_nmos L=0.52u W=0.15u AS=0.162p AD=0.0855p
+ PS=2.16u PD=1.14u
M$18 VSS OUTN$4 OUTP$4 VSS sg13_lv_nmos L=0.52u W=0.15u AS=0.0855p AD=0.162p
+ PS=1.14u PD=2.16u
M$19 OUTP$76 OUTN$76 VSS VSS sg13_lv_nmos L=0.52u W=0.15u AS=0.162p AD=0.0855p
+ PS=2.16u PD=1.14u
M$20 VSS OUTP$76 OUTN$76 VSS sg13_lv_nmos L=0.52u W=0.15u AS=0.0855p AD=0.162p
+ PS=1.14u PD=2.16u
M$21 OUTP$77 OUTN$77 VSS VSS sg13_lv_nmos L=0.52u W=0.15u AS=0.162p AD=0.0855p
+ PS=2.16u PD=1.14u
M$22 VSS OUTP$77 OUTN$77 VSS sg13_lv_nmos L=0.52u W=0.15u AS=0.0855p AD=0.162p
+ PS=1.14u PD=2.16u
M$23 OUTN$5 OUTP$5 VSS VSS sg13_lv_nmos L=0.52u W=0.15u AS=0.162p AD=0.0855p
+ PS=2.16u PD=1.14u
M$24 VSS OUTN$5 OUTP$5 VSS sg13_lv_nmos L=0.52u W=0.15u AS=0.0855p AD=0.162p
+ PS=1.14u PD=2.16u
M$25 OUTP$78 OUTN$78 VSS VSS sg13_lv_nmos L=0.52u W=0.15u AS=0.162p AD=0.0855p
+ PS=2.16u PD=1.14u
M$26 VSS OUTP$78 OUTN$78 VSS sg13_lv_nmos L=0.52u W=0.15u AS=0.0855p AD=0.162p
+ PS=1.14u PD=2.16u
M$27 OUTN$6 OUTP$6 VSS VSS sg13_lv_nmos L=0.52u W=0.15u AS=0.162p AD=0.0855p
+ PS=2.16u PD=1.14u
M$28 VSS OUTN$6 OUTP$6 VSS sg13_lv_nmos L=0.52u W=0.15u AS=0.0855p AD=0.162p
+ PS=1.14u PD=2.16u
M$29 OUTN$7 OUTP$7 VSS VSS sg13_lv_nmos L=0.52u W=0.15u AS=0.162p AD=0.0855p
+ PS=2.16u PD=1.14u
M$30 VSS OUTN$7 OUTP$7 VSS sg13_lv_nmos L=0.52u W=0.15u AS=0.0855p AD=0.162p
+ PS=1.14u PD=2.16u
M$31 OUTP$79 OUTN$79 VSS VSS sg13_lv_nmos L=0.52u W=0.15u AS=0.162p AD=0.0855p
+ PS=2.16u PD=1.14u
M$32 VSS OUTP$79 OUTN$79 VSS sg13_lv_nmos L=0.52u W=0.15u AS=0.0855p AD=0.162p
+ PS=1.14u PD=2.16u
M$33 OUTP$80 OUTN$80 VSS VSS sg13_lv_nmos L=0.52u W=0.15u AS=0.162p AD=0.0855p
+ PS=2.16u PD=1.14u
M$34 VSS OUTP$80 OUTN$80 VSS sg13_lv_nmos L=0.52u W=0.15u AS=0.0855p AD=0.162p
+ PS=1.14u PD=2.16u
M$35 OUTN$8 OUTP$8 VSS VSS sg13_lv_nmos L=0.52u W=0.15u AS=0.162p AD=0.0855p
+ PS=2.16u PD=1.14u
M$36 VSS OUTN$8 OUTP$8 VSS sg13_lv_nmos L=0.52u W=0.15u AS=0.0855p AD=0.162p
+ PS=1.14u PD=2.16u
M$37 OUTN$9 OUTP$9 VSS VSS sg13_lv_nmos L=0.52u W=0.15u AS=0.162p AD=0.0855p
+ PS=2.16u PD=1.14u
M$38 VSS OUTN$9 OUTP$9 VSS sg13_lv_nmos L=0.52u W=0.15u AS=0.0855p AD=0.162p
+ PS=1.14u PD=2.16u
M$39 OUTP$81 OUTN$81 VSS VSS sg13_lv_nmos L=0.52u W=0.15u AS=0.162p AD=0.0855p
+ PS=2.16u PD=1.14u
M$40 VSS OUTP$81 OUTN$81 VSS sg13_lv_nmos L=0.52u W=0.15u AS=0.0855p AD=0.162p
+ PS=1.14u PD=2.16u
M$41 OUTN$10 OUTP$10 VSS VSS sg13_lv_nmos L=0.52u W=0.15u AS=0.162p AD=0.0855p
+ PS=2.16u PD=1.14u
M$42 VSS OUTN$10 OUTP$10 VSS sg13_lv_nmos L=0.52u W=0.15u AS=0.0855p AD=0.162p
+ PS=1.14u PD=2.16u
M$43 OUTP$82 OUTN$82 VSS VSS sg13_lv_nmos L=0.52u W=0.15u AS=0.162p AD=0.0855p
+ PS=2.16u PD=1.14u
M$44 VSS OUTP$82 OUTN$82 VSS sg13_lv_nmos L=0.52u W=0.15u AS=0.0855p AD=0.162p
+ PS=1.14u PD=2.16u
M$45 OUTP$83 OUTN$83 VSS VSS sg13_lv_nmos L=0.52u W=0.15u AS=0.162p AD=0.0855p
+ PS=2.16u PD=1.14u
M$46 VSS OUTP$83 OUTN$83 VSS sg13_lv_nmos L=0.52u W=0.15u AS=0.0855p AD=0.162p
+ PS=1.14u PD=2.16u
M$47 OUTN$11 OUTP$11 VSS VSS sg13_lv_nmos L=0.52u W=0.15u AS=0.162p AD=0.0855p
+ PS=2.16u PD=1.14u
M$48 VSS OUTN$11 OUTP$11 VSS sg13_lv_nmos L=0.52u W=0.15u AS=0.0855p AD=0.162p
+ PS=1.14u PD=2.16u
M$49 OUTP$84 OUTN$84 VSS VSS sg13_lv_nmos L=0.52u W=0.15u AS=0.162p AD=0.0855p
+ PS=2.16u PD=1.14u
M$50 VSS OUTP$84 OUTN$84 VSS sg13_lv_nmos L=0.52u W=0.15u AS=0.0855p AD=0.162p
+ PS=1.14u PD=2.16u
M$51 OUTN$12 OUTP$12 VSS VSS sg13_lv_nmos L=0.52u W=0.15u AS=0.162p AD=0.0855p
+ PS=2.16u PD=1.14u
M$52 VSS OUTN$12 OUTP$12 VSS sg13_lv_nmos L=0.52u W=0.15u AS=0.0855p AD=0.162p
+ PS=1.14u PD=2.16u
M$53 OUTN$13 OUTP$13 VSS VSS sg13_lv_nmos L=0.52u W=0.15u AS=0.162p AD=0.0855p
+ PS=2.16u PD=1.14u
M$54 VSS OUTN$13 OUTP$13 VSS sg13_lv_nmos L=0.52u W=0.15u AS=0.0855p AD=0.162p
+ PS=1.14u PD=2.16u
M$55 OUTP$85 OUTN$85 VSS VSS sg13_lv_nmos L=0.52u W=0.15u AS=0.162p AD=0.0855p
+ PS=2.16u PD=1.14u
M$56 VSS OUTP$85 OUTN$85 VSS sg13_lv_nmos L=0.52u W=0.15u AS=0.0855p AD=0.162p
+ PS=1.14u PD=2.16u
M$57 OUTP$86 OUTN$86 VSS VSS sg13_lv_nmos L=0.52u W=0.15u AS=0.162p AD=0.0855p
+ PS=2.16u PD=1.14u
M$58 VSS OUTP$86 OUTN$86 VSS sg13_lv_nmos L=0.52u W=0.15u AS=0.0855p AD=0.162p
+ PS=1.14u PD=2.16u
M$59 OUTN$14 OUTP$14 VSS VSS sg13_lv_nmos L=0.52u W=0.15u AS=0.162p AD=0.0855p
+ PS=2.16u PD=1.14u
M$60 VSS OUTN$14 OUTP$14 VSS sg13_lv_nmos L=0.52u W=0.15u AS=0.0855p AD=0.162p
+ PS=1.14u PD=2.16u
M$61 OUTP$87 OUTN$87 VSS VSS sg13_lv_nmos L=0.52u W=0.15u AS=0.162p AD=0.0855p
+ PS=2.16u PD=1.14u
M$62 VSS OUTP$87 OUTN$87 VSS sg13_lv_nmos L=0.52u W=0.15u AS=0.0855p AD=0.162p
+ PS=1.14u PD=2.16u
M$63 OUTN$15 OUTP$15 VSS VSS sg13_lv_nmos L=0.52u W=0.15u AS=0.162p AD=0.0855p
+ PS=2.16u PD=1.14u
M$64 VSS OUTN$15 OUTP$15 VSS sg13_lv_nmos L=0.52u W=0.15u AS=0.0855p AD=0.162p
+ PS=1.14u PD=2.16u
M$65 OUTN$16 OUTP$16 VSS VSS sg13_lv_nmos L=0.52u W=0.15u AS=0.162p AD=0.0855p
+ PS=2.16u PD=1.14u
M$66 VSS OUTN$16 OUTP$16 VSS sg13_lv_nmos L=0.52u W=0.15u AS=0.0855p AD=0.162p
+ PS=1.14u PD=2.16u
M$67 OUTP$88 OUTN$88 VSS VSS sg13_lv_nmos L=0.52u W=0.15u AS=0.162p AD=0.0855p
+ PS=2.16u PD=1.14u
M$68 VSS OUTP$88 OUTN$88 VSS sg13_lv_nmos L=0.52u W=0.15u AS=0.0855p AD=0.162p
+ PS=1.14u PD=2.16u
M$69 OUTP$89 OUTN$89 VSS VSS sg13_lv_nmos L=0.52u W=0.15u AS=0.162p AD=0.0855p
+ PS=2.16u PD=1.14u
M$70 VSS OUTP$89 OUTN$89 VSS sg13_lv_nmos L=0.52u W=0.15u AS=0.0855p AD=0.162p
+ PS=1.14u PD=2.16u
M$71 OUTN$17 OUTP$17 VSS VSS sg13_lv_nmos L=0.52u W=0.15u AS=0.162p AD=0.0855p
+ PS=2.16u PD=1.14u
M$72 VSS OUTN$17 OUTP$17 VSS sg13_lv_nmos L=0.52u W=0.15u AS=0.0855p AD=0.162p
+ PS=1.14u PD=2.16u
M$73 OUTP$90 OUTN$90 VSS VSS sg13_lv_nmos L=0.52u W=0.15u AS=0.162p AD=0.0855p
+ PS=2.16u PD=1.14u
M$74 VSS OUTP$90 OUTN$90 VSS sg13_lv_nmos L=0.52u W=0.15u AS=0.0855p AD=0.162p
+ PS=1.14u PD=2.16u
M$75 OUTN$18 OUTP$18 VSS VSS sg13_lv_nmos L=0.52u W=0.15u AS=0.162p AD=0.0855p
+ PS=2.16u PD=1.14u
M$76 VSS OUTN$18 OUTP$18 VSS sg13_lv_nmos L=0.52u W=0.15u AS=0.0855p AD=0.162p
+ PS=1.14u PD=2.16u
M$77 OUTP$91 OUTN$91 VSS VSS sg13_lv_nmos L=0.52u W=0.15u AS=0.162p AD=0.0855p
+ PS=2.16u PD=1.14u
M$78 VSS OUTP$91 OUTN$91 VSS sg13_lv_nmos L=0.52u W=0.15u AS=0.0855p AD=0.162p
+ PS=1.14u PD=2.16u
M$79 OUTN$19 OUTP$19 VSS VSS sg13_lv_nmos L=0.52u W=0.15u AS=0.162p AD=0.0855p
+ PS=2.16u PD=1.14u
M$80 VSS OUTN$19 OUTP$19 VSS sg13_lv_nmos L=0.52u W=0.15u AS=0.0855p AD=0.162p
+ PS=1.14u PD=2.16u
M$81 OUTN$20 OUTP$20 VSS VSS sg13_lv_nmos L=0.52u W=0.15u AS=0.162p AD=0.0855p
+ PS=2.16u PD=1.14u
M$82 VSS OUTN$20 OUTP$20 VSS sg13_lv_nmos L=0.52u W=0.15u AS=0.0855p AD=0.162p
+ PS=1.14u PD=2.16u
M$83 OUTP$92 OUTN$92 VSS VSS sg13_lv_nmos L=0.52u W=0.15u AS=0.162p AD=0.0855p
+ PS=2.16u PD=1.14u
M$84 VSS OUTP$92 OUTN$92 VSS sg13_lv_nmos L=0.52u W=0.15u AS=0.0855p AD=0.162p
+ PS=1.14u PD=2.16u
M$85 OUTN$21 OUTP$21 VSS VSS sg13_lv_nmos L=0.52u W=0.15u AS=0.162p AD=0.0855p
+ PS=2.16u PD=1.14u
M$86 VSS OUTN$21 OUTP$21 VSS sg13_lv_nmos L=0.52u W=0.15u AS=0.0855p AD=0.162p
+ PS=1.14u PD=2.16u
M$87 OUTP$93 OUTN$93 VSS VSS sg13_lv_nmos L=0.52u W=0.15u AS=0.162p AD=0.0855p
+ PS=2.16u PD=1.14u
M$88 VSS OUTP$93 OUTN$93 VSS sg13_lv_nmos L=0.52u W=0.15u AS=0.0855p AD=0.162p
+ PS=1.14u PD=2.16u
M$89 OUTP$94 OUTN$94 VSS VSS sg13_lv_nmos L=0.52u W=0.15u AS=0.162p AD=0.0855p
+ PS=2.16u PD=1.14u
M$90 VSS OUTP$94 OUTN$94 VSS sg13_lv_nmos L=0.52u W=0.15u AS=0.0855p AD=0.162p
+ PS=1.14u PD=2.16u
M$91 OUTN$22 OUTP$22 VSS VSS sg13_lv_nmos L=0.52u W=0.15u AS=0.162p AD=0.0855p
+ PS=2.16u PD=1.14u
M$92 VSS OUTN$22 OUTP$22 VSS sg13_lv_nmos L=0.52u W=0.15u AS=0.0855p AD=0.162p
+ PS=1.14u PD=2.16u
M$93 OUTN$23 OUTP$23 VSS VSS sg13_lv_nmos L=0.52u W=0.15u AS=0.162p AD=0.0855p
+ PS=2.16u PD=1.14u
M$94 VSS OUTN$23 OUTP$23 VSS sg13_lv_nmos L=0.52u W=0.15u AS=0.0855p AD=0.162p
+ PS=1.14u PD=2.16u
M$95 OUTP$95 OUTN$95 VSS VSS sg13_lv_nmos L=0.52u W=0.15u AS=0.162p AD=0.0855p
+ PS=2.16u PD=1.14u
M$96 VSS OUTP$95 OUTN$95 VSS sg13_lv_nmos L=0.52u W=0.15u AS=0.0855p AD=0.162p
+ PS=1.14u PD=2.16u
M$97 OUTN$24 OUTP$24 VSS VSS sg13_lv_nmos L=0.52u W=0.15u AS=0.162p AD=0.0855p
+ PS=2.16u PD=1.14u
M$98 VSS OUTN$24 OUTP$24 VSS sg13_lv_nmos L=0.52u W=0.15u AS=0.0855p AD=0.162p
+ PS=1.14u PD=2.16u
M$99 OUTP$96 OUTN$96 VSS VSS sg13_lv_nmos L=0.52u W=0.15u AS=0.162p AD=0.0855p
+ PS=2.16u PD=1.14u
M$100 VSS OUTP$96 OUTN$96 VSS sg13_lv_nmos L=0.52u W=0.15u AS=0.0855p AD=0.162p
+ PS=1.14u PD=2.16u
M$101 OUTN$25 OUTP$25 VSS VSS sg13_lv_nmos L=0.52u W=0.15u AS=0.162p AD=0.0855p
+ PS=2.16u PD=1.14u
M$102 VSS OUTN$25 OUTP$25 VSS sg13_lv_nmos L=0.52u W=0.15u AS=0.0855p AD=0.162p
+ PS=1.14u PD=2.16u
M$103 OUTP$97 OUTN$97 VSS VSS sg13_lv_nmos L=0.52u W=0.15u AS=0.162p AD=0.0855p
+ PS=2.16u PD=1.14u
M$104 VSS OUTP$97 OUTN$97 VSS sg13_lv_nmos L=0.52u W=0.15u AS=0.0855p AD=0.162p
+ PS=1.14u PD=2.16u
M$105 OUTP$98 OUTN$98 VSS VSS sg13_lv_nmos L=0.52u W=0.15u AS=0.162p AD=0.0855p
+ PS=2.16u PD=1.14u
M$106 VSS OUTP$98 OUTN$98 VSS sg13_lv_nmos L=0.52u W=0.15u AS=0.0855p AD=0.162p
+ PS=1.14u PD=2.16u
M$107 OUTN$26 OUTP$26 VSS VSS sg13_lv_nmos L=0.52u W=0.15u AS=0.162p AD=0.0855p
+ PS=2.16u PD=1.14u
M$108 VSS OUTN$26 OUTP$26 VSS sg13_lv_nmos L=0.52u W=0.15u AS=0.0855p AD=0.162p
+ PS=1.14u PD=2.16u
M$109 OUTN$27 OUTP$27 VSS VSS sg13_lv_nmos L=0.52u W=0.15u AS=0.162p AD=0.0855p
+ PS=2.16u PD=1.14u
M$110 VSS OUTN$27 OUTP$27 VSS sg13_lv_nmos L=0.52u W=0.15u AS=0.0855p AD=0.162p
+ PS=1.14u PD=2.16u
M$111 OUTP$99 OUTN$99 VSS VSS sg13_lv_nmos L=0.52u W=0.15u AS=0.162p AD=0.0855p
+ PS=2.16u PD=1.14u
M$112 VSS OUTP$99 OUTN$99 VSS sg13_lv_nmos L=0.52u W=0.15u AS=0.0855p AD=0.162p
+ PS=1.14u PD=2.16u
M$113 OUTP$100 OUTN$100 VSS VSS sg13_lv_nmos L=0.52u W=0.15u AS=0.162p
+ AD=0.0855p PS=2.16u PD=1.14u
M$114 VSS OUTP$100 OUTN$100 VSS sg13_lv_nmos L=0.52u W=0.15u AS=0.0855p
+ AD=0.162p PS=1.14u PD=2.16u
M$115 OUTN$28 OUTP$28 VSS VSS sg13_lv_nmos L=0.52u W=0.15u AS=0.162p AD=0.0855p
+ PS=2.16u PD=1.14u
M$116 VSS OUTN$28 OUTP$28 VSS sg13_lv_nmos L=0.52u W=0.15u AS=0.0855p AD=0.162p
+ PS=1.14u PD=2.16u
M$117 OUTN$29 OUTP$29 VSS VSS sg13_lv_nmos L=0.52u W=0.15u AS=0.162p AD=0.0855p
+ PS=2.16u PD=1.14u
M$118 VSS OUTN$29 OUTP$29 VSS sg13_lv_nmos L=0.52u W=0.15u AS=0.0855p AD=0.162p
+ PS=1.14u PD=2.16u
M$119 OUTP$101 OUTN$101 VSS VSS sg13_lv_nmos L=0.52u W=0.15u AS=0.162p
+ AD=0.0855p PS=2.16u PD=1.14u
M$120 VSS OUTP$101 OUTN$101 VSS sg13_lv_nmos L=0.52u W=0.15u AS=0.0855p
+ AD=0.162p PS=1.14u PD=2.16u
M$121 OUTN$30 OUTP$30 VSS VSS sg13_lv_nmos L=0.52u W=0.15u AS=0.162p AD=0.0855p
+ PS=2.16u PD=1.14u
M$122 VSS OUTN$30 OUTP$30 VSS sg13_lv_nmos L=0.52u W=0.15u AS=0.0855p AD=0.162p
+ PS=1.14u PD=2.16u
M$123 OUTP$102 OUTN$102 VSS VSS sg13_lv_nmos L=0.52u W=0.15u AS=0.162p
+ AD=0.0855p PS=2.16u PD=1.14u
M$124 VSS OUTP$102 OUTN$102 VSS sg13_lv_nmos L=0.52u W=0.15u AS=0.0855p
+ AD=0.162p PS=1.14u PD=2.16u
M$125 OUTP$103 OUTN$103 VSS VSS sg13_lv_nmos L=0.52u W=0.15u AS=0.162p
+ AD=0.0855p PS=2.16u PD=1.14u
M$126 VSS OUTP$103 OUTN$103 VSS sg13_lv_nmos L=0.52u W=0.15u AS=0.0855p
+ AD=0.162p PS=1.14u PD=2.16u
M$127 OUTN$31 OUTP$31 VSS VSS sg13_lv_nmos L=0.52u W=0.15u AS=0.162p AD=0.0855p
+ PS=2.16u PD=1.14u
M$128 VSS OUTN$31 OUTP$31 VSS sg13_lv_nmos L=0.52u W=0.15u AS=0.0855p AD=0.162p
+ PS=1.14u PD=2.16u
M$129 OUTP$104 OUTN$104 VSS VSS sg13_lv_nmos L=0.52u W=0.15u AS=0.162p
+ AD=0.0855p PS=2.16u PD=1.14u
M$130 VSS OUTP$104 OUTN$104 VSS sg13_lv_nmos L=0.52u W=0.15u AS=0.0855p
+ AD=0.162p PS=1.14u PD=2.16u
M$131 OUTN$32 OUTP$32 VSS VSS sg13_lv_nmos L=0.52u W=0.15u AS=0.162p AD=0.0855p
+ PS=2.16u PD=1.14u
M$132 VSS OUTN$32 OUTP$32 VSS sg13_lv_nmos L=0.52u W=0.15u AS=0.0855p AD=0.162p
+ PS=1.14u PD=2.16u
M$133 OUTP$105 OUTN$105 VSS VSS sg13_lv_nmos L=0.52u W=0.15u AS=0.162p
+ AD=0.0855p PS=2.16u PD=1.14u
M$134 VSS OUTP$105 OUTN$105 VSS sg13_lv_nmos L=0.52u W=0.15u AS=0.0855p
+ AD=0.162p PS=1.14u PD=2.16u
M$135 OUTN$33 OUTP$33 VSS VSS sg13_lv_nmos L=0.52u W=0.15u AS=0.162p AD=0.0855p
+ PS=2.16u PD=1.14u
M$136 VSS OUTN$33 OUTP$33 VSS sg13_lv_nmos L=0.52u W=0.15u AS=0.0855p AD=0.162p
+ PS=1.14u PD=2.16u
M$137 OUTN$34 OUTP$34 VSS VSS sg13_lv_nmos L=0.52u W=0.15u AS=0.162p AD=0.0855p
+ PS=2.16u PD=1.14u
M$138 VSS OUTN$34 OUTP$34 VSS sg13_lv_nmos L=0.52u W=0.15u AS=0.0855p AD=0.162p
+ PS=1.14u PD=2.16u
M$139 OUTP$106 OUTN$106 VSS VSS sg13_lv_nmos L=0.52u W=0.15u AS=0.162p
+ AD=0.0855p PS=2.16u PD=1.14u
M$140 VSS OUTP$106 OUTN$106 VSS sg13_lv_nmos L=0.52u W=0.15u AS=0.0855p
+ AD=0.162p PS=1.14u PD=2.16u
M$141 OUTN$35 OUTP$35 VSS VSS sg13_lv_nmos L=0.52u W=0.15u AS=0.162p AD=0.0855p
+ PS=2.16u PD=1.14u
M$142 VSS OUTN$35 OUTP$35 VSS sg13_lv_nmos L=0.52u W=0.15u AS=0.0855p AD=0.162p
+ PS=1.14u PD=2.16u
M$143 OUTP$107 OUTN$107 VSS VSS sg13_lv_nmos L=0.52u W=0.15u AS=0.162p
+ AD=0.0855p PS=2.16u PD=1.14u
M$144 VSS OUTP$107 OUTN$107 VSS sg13_lv_nmos L=0.52u W=0.15u AS=0.0855p
+ AD=0.162p PS=1.14u PD=2.16u
M$145 OUTP$108 OUTN$108 VSS VSS sg13_lv_nmos L=0.52u W=0.15u AS=0.162p
+ AD=0.0855p PS=2.16u PD=1.14u
M$146 VSS OUTP$108 OUTN$108 VSS sg13_lv_nmos L=0.52u W=0.15u AS=0.0855p
+ AD=0.162p PS=1.14u PD=2.16u
M$147 OUTN$36 OUTP$36 VSS VSS sg13_lv_nmos L=0.52u W=0.15u AS=0.162p AD=0.0855p
+ PS=2.16u PD=1.14u
M$148 VSS OUTN$36 OUTP$36 VSS sg13_lv_nmos L=0.52u W=0.15u AS=0.0855p AD=0.162p
+ PS=1.14u PD=2.16u
M$149 OUTP$109 OUTN$109 VSS VSS sg13_lv_nmos L=0.52u W=0.15u AS=0.162p
+ AD=0.0855p PS=2.16u PD=1.14u
M$150 VSS OUTP$109 OUTN$109 VSS sg13_lv_nmos L=0.52u W=0.15u AS=0.0855p
+ AD=0.162p PS=1.14u PD=2.16u
M$151 OUTN$37 OUTP$37 VSS VSS sg13_lv_nmos L=0.52u W=0.15u AS=0.162p AD=0.0855p
+ PS=2.16u PD=1.14u
M$152 VSS OUTN$37 OUTP$37 VSS sg13_lv_nmos L=0.52u W=0.15u AS=0.0855p AD=0.162p
+ PS=1.14u PD=2.16u
M$153 OUTN$38 OUTP$38 VSS VSS sg13_lv_nmos L=0.52u W=0.15u AS=0.162p AD=0.0855p
+ PS=2.16u PD=1.14u
M$154 VSS OUTN$38 OUTP$38 VSS sg13_lv_nmos L=0.52u W=0.15u AS=0.0855p AD=0.162p
+ PS=1.14u PD=2.16u
M$155 OUTP$110 OUTN$110 VSS VSS sg13_lv_nmos L=0.52u W=0.15u AS=0.162p
+ AD=0.0855p PS=2.16u PD=1.14u
M$156 VSS OUTP$110 OUTN$110 VSS sg13_lv_nmos L=0.52u W=0.15u AS=0.0855p
+ AD=0.162p PS=1.14u PD=2.16u
M$157 OUTN$39 OUTP$39 VSS VSS sg13_lv_nmos L=0.52u W=0.15u AS=0.162p AD=0.0855p
+ PS=2.16u PD=1.14u
M$158 VSS OUTN$39 OUTP$39 VSS sg13_lv_nmos L=0.52u W=0.15u AS=0.0855p AD=0.162p
+ PS=1.14u PD=2.16u
M$159 OUTP$111 OUTN$111 VSS VSS sg13_lv_nmos L=0.52u W=0.15u AS=0.162p
+ AD=0.0855p PS=2.16u PD=1.14u
M$160 VSS OUTP$111 OUTN$111 VSS sg13_lv_nmos L=0.52u W=0.15u AS=0.0855p
+ AD=0.162p PS=1.14u PD=2.16u
M$161 OUTN$40 OUTP$40 VSS VSS sg13_lv_nmos L=0.52u W=0.15u AS=0.162p AD=0.0855p
+ PS=2.16u PD=1.14u
M$162 VSS OUTN$40 OUTP$40 VSS sg13_lv_nmos L=0.52u W=0.15u AS=0.0855p AD=0.162p
+ PS=1.14u PD=2.16u
M$163 OUTP$112 OUTN$112 VSS VSS sg13_lv_nmos L=0.52u W=0.15u AS=0.162p
+ AD=0.0855p PS=2.16u PD=1.14u
M$164 VSS OUTP$112 OUTN$112 VSS sg13_lv_nmos L=0.52u W=0.15u AS=0.0855p
+ AD=0.162p PS=1.14u PD=2.16u
M$165 OUTN$41 OUTP$41 VSS VSS sg13_lv_nmos L=0.52u W=0.15u AS=0.162p AD=0.0855p
+ PS=2.16u PD=1.14u
M$166 VSS OUTN$41 OUTP$41 VSS sg13_lv_nmos L=0.52u W=0.15u AS=0.0855p AD=0.162p
+ PS=1.14u PD=2.16u
M$167 OUTP$113 OUTN$113 VSS VSS sg13_lv_nmos L=0.52u W=0.15u AS=0.162p
+ AD=0.0855p PS=2.16u PD=1.14u
M$168 VSS OUTP$113 OUTN$113 VSS sg13_lv_nmos L=0.52u W=0.15u AS=0.0855p
+ AD=0.162p PS=1.14u PD=2.16u
M$169 OUTP$114 OUTN$114 VSS VSS sg13_lv_nmos L=0.52u W=0.15u AS=0.162p
+ AD=0.0855p PS=2.16u PD=1.14u
M$170 VSS OUTP$114 OUTN$114 VSS sg13_lv_nmos L=0.52u W=0.15u AS=0.0855p
+ AD=0.162p PS=1.14u PD=2.16u
M$171 OUTN$42 OUTP$42 VSS VSS sg13_lv_nmos L=0.52u W=0.15u AS=0.162p AD=0.0855p
+ PS=2.16u PD=1.14u
M$172 VSS OUTN$42 OUTP$42 VSS sg13_lv_nmos L=0.52u W=0.15u AS=0.0855p AD=0.162p
+ PS=1.14u PD=2.16u
M$173 OUTP$115 OUTN$115 VSS VSS sg13_lv_nmos L=0.52u W=0.15u AS=0.162p
+ AD=0.0855p PS=2.16u PD=1.14u
M$174 VSS OUTP$115 OUTN$115 VSS sg13_lv_nmos L=0.52u W=0.15u AS=0.0855p
+ AD=0.162p PS=1.14u PD=2.16u
M$175 OUTN$43 OUTP$43 VSS VSS sg13_lv_nmos L=0.52u W=0.15u AS=0.162p AD=0.0855p
+ PS=2.16u PD=1.14u
M$176 VSS OUTN$43 OUTP$43 VSS sg13_lv_nmos L=0.52u W=0.15u AS=0.0855p AD=0.162p
+ PS=1.14u PD=2.16u
M$177 OUTN$44 OUTP$44 VSS VSS sg13_lv_nmos L=0.52u W=0.15u AS=0.162p AD=0.0855p
+ PS=2.16u PD=1.14u
M$178 VSS OUTN$44 OUTP$44 VSS sg13_lv_nmos L=0.52u W=0.15u AS=0.0855p AD=0.162p
+ PS=1.14u PD=2.16u
M$179 OUTP$116 OUTN$116 VSS VSS sg13_lv_nmos L=0.52u W=0.15u AS=0.162p
+ AD=0.0855p PS=2.16u PD=1.14u
M$180 VSS OUTP$116 OUTN$116 VSS sg13_lv_nmos L=0.52u W=0.15u AS=0.0855p
+ AD=0.162p PS=1.14u PD=2.16u
M$181 OUTN$45 OUTP$45 VSS VSS sg13_lv_nmos L=0.52u W=0.15u AS=0.162p AD=0.0855p
+ PS=2.16u PD=1.14u
M$182 VSS OUTN$45 OUTP$45 VSS sg13_lv_nmos L=0.52u W=0.15u AS=0.0855p AD=0.162p
+ PS=1.14u PD=2.16u
M$183 OUTP$117 OUTN$117 VSS VSS sg13_lv_nmos L=0.52u W=0.15u AS=0.162p
+ AD=0.0855p PS=2.16u PD=1.14u
M$184 VSS OUTP$117 OUTN$117 VSS sg13_lv_nmos L=0.52u W=0.15u AS=0.0855p
+ AD=0.162p PS=1.14u PD=2.16u
M$185 OUTP$118 OUTN$118 VSS VSS sg13_lv_nmos L=0.52u W=0.15u AS=0.162p
+ AD=0.0855p PS=2.16u PD=1.14u
M$186 VSS OUTP$118 OUTN$118 VSS sg13_lv_nmos L=0.52u W=0.15u AS=0.0855p
+ AD=0.162p PS=1.14u PD=2.16u
M$187 OUTN$46 OUTP$46 VSS VSS sg13_lv_nmos L=0.52u W=0.15u AS=0.162p AD=0.0855p
+ PS=2.16u PD=1.14u
M$188 VSS OUTN$46 OUTP$46 VSS sg13_lv_nmos L=0.52u W=0.15u AS=0.0855p AD=0.162p
+ PS=1.14u PD=2.16u
M$189 OUTN$47 OUTP$47 VSS VSS sg13_lv_nmos L=0.52u W=0.15u AS=0.162p AD=0.0855p
+ PS=2.16u PD=1.14u
M$190 VSS OUTN$47 OUTP$47 VSS sg13_lv_nmos L=0.52u W=0.15u AS=0.0855p AD=0.162p
+ PS=1.14u PD=2.16u
M$191 OUTP$119 OUTN$119 VSS VSS sg13_lv_nmos L=0.52u W=0.15u AS=0.162p
+ AD=0.0855p PS=2.16u PD=1.14u
M$192 VSS OUTP$119 OUTN$119 VSS sg13_lv_nmos L=0.52u W=0.15u AS=0.0855p
+ AD=0.162p PS=1.14u PD=2.16u
M$193 OUTP$120 OUTN$120 VSS VSS sg13_lv_nmos L=0.52u W=0.15u AS=0.162p
+ AD=0.0855p PS=2.16u PD=1.14u
M$194 VSS OUTP$120 OUTN$120 VSS sg13_lv_nmos L=0.52u W=0.15u AS=0.0855p
+ AD=0.162p PS=1.14u PD=2.16u
M$195 OUTN$48 OUTP$48 VSS VSS sg13_lv_nmos L=0.52u W=0.15u AS=0.162p AD=0.0855p
+ PS=2.16u PD=1.14u
M$196 VSS OUTN$48 OUTP$48 VSS sg13_lv_nmos L=0.52u W=0.15u AS=0.0855p AD=0.162p
+ PS=1.14u PD=2.16u
M$197 OUTP$121 OUTN$121 VSS VSS sg13_lv_nmos L=0.52u W=0.15u AS=0.162p
+ AD=0.0855p PS=2.16u PD=1.14u
M$198 VSS OUTP$121 OUTN$121 VSS sg13_lv_nmos L=0.52u W=0.15u AS=0.0855p
+ AD=0.162p PS=1.14u PD=2.16u
M$199 OUTN$49 OUTP$49 VSS VSS sg13_lv_nmos L=0.52u W=0.15u AS=0.162p AD=0.0855p
+ PS=2.16u PD=1.14u
M$200 VSS OUTN$49 OUTP$49 VSS sg13_lv_nmos L=0.52u W=0.15u AS=0.0855p AD=0.162p
+ PS=1.14u PD=2.16u
M$201 OUTP$122 OUTN$122 VSS VSS sg13_lv_nmos L=0.52u W=0.15u AS=0.162p
+ AD=0.0855p PS=2.16u PD=1.14u
M$202 VSS OUTP$122 OUTN$122 VSS sg13_lv_nmos L=0.52u W=0.15u AS=0.0855p
+ AD=0.162p PS=1.14u PD=2.16u
M$203 OUTN$50 OUTP$50 VSS VSS sg13_lv_nmos L=0.52u W=0.15u AS=0.162p AD=0.0855p
+ PS=2.16u PD=1.14u
M$204 VSS OUTN$50 OUTP$50 VSS sg13_lv_nmos L=0.52u W=0.15u AS=0.0855p AD=0.162p
+ PS=1.14u PD=2.16u
M$205 OUTN$51 OUTP$51 VSS VSS sg13_lv_nmos L=0.52u W=0.15u AS=0.162p AD=0.0855p
+ PS=2.16u PD=1.14u
M$206 VSS OUTN$51 OUTP$51 VSS sg13_lv_nmos L=0.52u W=0.15u AS=0.0855p AD=0.162p
+ PS=1.14u PD=2.16u
M$207 OUTP$123 OUTN$123 VSS VSS sg13_lv_nmos L=0.52u W=0.15u AS=0.162p
+ AD=0.0855p PS=2.16u PD=1.14u
M$208 VSS OUTP$123 OUTN$123 VSS sg13_lv_nmos L=0.52u W=0.15u AS=0.0855p
+ AD=0.162p PS=1.14u PD=2.16u
M$209 OUTN$52 OUTP$52 VSS VSS sg13_lv_nmos L=0.52u W=0.15u AS=0.162p AD=0.0855p
+ PS=2.16u PD=1.14u
M$210 VSS OUTN$52 OUTP$52 VSS sg13_lv_nmos L=0.52u W=0.15u AS=0.0855p AD=0.162p
+ PS=1.14u PD=2.16u
M$211 OUTP$124 OUTN$124 VSS VSS sg13_lv_nmos L=0.52u W=0.15u AS=0.162p
+ AD=0.0855p PS=2.16u PD=1.14u
M$212 VSS OUTP$124 OUTN$124 VSS sg13_lv_nmos L=0.52u W=0.15u AS=0.0855p
+ AD=0.162p PS=1.14u PD=2.16u
M$213 OUTN$53 OUTP$53 VSS VSS sg13_lv_nmos L=0.52u W=0.15u AS=0.162p AD=0.0855p
+ PS=2.16u PD=1.14u
M$214 VSS OUTN$53 OUTP$53 VSS sg13_lv_nmos L=0.52u W=0.15u AS=0.0855p AD=0.162p
+ PS=1.14u PD=2.16u
M$215 OUTP$125 OUTN$125 VSS VSS sg13_lv_nmos L=0.52u W=0.15u AS=0.162p
+ AD=0.0855p PS=2.16u PD=1.14u
M$216 VSS OUTP$125 OUTN$125 VSS sg13_lv_nmos L=0.52u W=0.15u AS=0.0855p
+ AD=0.162p PS=1.14u PD=2.16u
M$217 OUTN$54 OUTP$54 VSS VSS sg13_lv_nmos L=0.52u W=0.15u AS=0.162p AD=0.0855p
+ PS=2.16u PD=1.14u
M$218 VSS OUTN$54 OUTP$54 VSS sg13_lv_nmos L=0.52u W=0.15u AS=0.0855p AD=0.162p
+ PS=1.14u PD=2.16u
M$219 OUTP$126 OUTN$126 VSS VSS sg13_lv_nmos L=0.52u W=0.15u AS=0.162p
+ AD=0.0855p PS=2.16u PD=1.14u
M$220 VSS OUTP$126 OUTN$126 VSS sg13_lv_nmos L=0.52u W=0.15u AS=0.0855p
+ AD=0.162p PS=1.14u PD=2.16u
M$221 OUTN$55 OUTP$55 VSS VSS sg13_lv_nmos L=0.52u W=0.15u AS=0.162p AD=0.0855p
+ PS=2.16u PD=1.14u
M$222 VSS OUTN$55 OUTP$55 VSS sg13_lv_nmos L=0.52u W=0.15u AS=0.0855p AD=0.162p
+ PS=1.14u PD=2.16u
M$223 OUTP$127 OUTN$127 VSS VSS sg13_lv_nmos L=0.52u W=0.15u AS=0.162p
+ AD=0.0855p PS=2.16u PD=1.14u
M$224 VSS OUTP$127 OUTN$127 VSS sg13_lv_nmos L=0.52u W=0.15u AS=0.0855p
+ AD=0.162p PS=1.14u PD=2.16u
M$225 OUTN$56 OUTP$56 VSS VSS sg13_lv_nmos L=0.52u W=0.15u AS=0.162p AD=0.0855p
+ PS=2.16u PD=1.14u
M$226 VSS OUTN$56 OUTP$56 VSS sg13_lv_nmos L=0.52u W=0.15u AS=0.0855p AD=0.162p
+ PS=1.14u PD=2.16u
M$227 OUTP$128 OUTN$128 VSS VSS sg13_lv_nmos L=0.52u W=0.15u AS=0.162p
+ AD=0.0855p PS=2.16u PD=1.14u
M$228 VSS OUTP$128 OUTN$128 VSS sg13_lv_nmos L=0.52u W=0.15u AS=0.0855p
+ AD=0.162p PS=1.14u PD=2.16u
M$229 OUTP$129 OUTN$129 VSS VSS sg13_lv_nmos L=0.52u W=0.15u AS=0.162p
+ AD=0.0855p PS=2.16u PD=1.14u
M$230 VSS OUTP$129 OUTN$129 VSS sg13_lv_nmos L=0.52u W=0.15u AS=0.0855p
+ AD=0.162p PS=1.14u PD=2.16u
M$231 OUTN$57 OUTP$57 VSS VSS sg13_lv_nmos L=0.52u W=0.15u AS=0.162p AD=0.0855p
+ PS=2.16u PD=1.14u
M$232 VSS OUTN$57 OUTP$57 VSS sg13_lv_nmos L=0.52u W=0.15u AS=0.0855p AD=0.162p
+ PS=1.14u PD=2.16u
M$233 OUTN$58 OUTP$58 VSS VSS sg13_lv_nmos L=0.52u W=0.15u AS=0.162p AD=0.0855p
+ PS=2.16u PD=1.14u
M$234 VSS OUTN$58 OUTP$58 VSS sg13_lv_nmos L=0.52u W=0.15u AS=0.0855p AD=0.162p
+ PS=1.14u PD=2.16u
M$235 OUTP$130 OUTN$130 VSS VSS sg13_lv_nmos L=0.52u W=0.15u AS=0.162p
+ AD=0.0855p PS=2.16u PD=1.14u
M$236 VSS OUTP$130 OUTN$130 VSS sg13_lv_nmos L=0.52u W=0.15u AS=0.0855p
+ AD=0.162p PS=1.14u PD=2.16u
M$237 OUTN$59 OUTP$59 VSS VSS sg13_lv_nmos L=0.52u W=0.15u AS=0.162p AD=0.0855p
+ PS=2.16u PD=1.14u
M$238 VSS OUTN$59 OUTP$59 VSS sg13_lv_nmos L=0.52u W=0.15u AS=0.0855p AD=0.162p
+ PS=1.14u PD=2.16u
M$239 OUTP$131 OUTN$131 VSS VSS sg13_lv_nmos L=0.52u W=0.15u AS=0.162p
+ AD=0.0855p PS=2.16u PD=1.14u
M$240 VSS OUTP$131 OUTN$131 VSS sg13_lv_nmos L=0.52u W=0.15u AS=0.0855p
+ AD=0.162p PS=1.14u PD=2.16u
M$241 OUTP$132 OUTN$132 VSS VSS sg13_lv_nmos L=0.52u W=0.15u AS=0.162p
+ AD=0.0855p PS=2.16u PD=1.14u
M$242 VSS OUTP$132 OUTN$132 VSS sg13_lv_nmos L=0.52u W=0.15u AS=0.0855p
+ AD=0.162p PS=1.14u PD=2.16u
M$243 OUTN$60 OUTP$60 VSS VSS sg13_lv_nmos L=0.52u W=0.15u AS=0.162p AD=0.0855p
+ PS=2.16u PD=1.14u
M$244 VSS OUTN$60 OUTP$60 VSS sg13_lv_nmos L=0.52u W=0.15u AS=0.0855p AD=0.162p
+ PS=1.14u PD=2.16u
M$245 OUTP$133 OUTN$133 VSS VSS sg13_lv_nmos L=0.52u W=0.15u AS=0.162p
+ AD=0.0855p PS=2.16u PD=1.14u
M$246 VSS OUTP$133 OUTN$133 VSS sg13_lv_nmos L=0.52u W=0.15u AS=0.0855p
+ AD=0.162p PS=1.14u PD=2.16u
M$247 OUTN$61 OUTP$61 VSS VSS sg13_lv_nmos L=0.52u W=0.15u AS=0.162p AD=0.0855p
+ PS=2.16u PD=1.14u
M$248 VSS OUTN$61 OUTP$61 VSS sg13_lv_nmos L=0.52u W=0.15u AS=0.0855p AD=0.162p
+ PS=1.14u PD=2.16u
M$249 OUTN$62 OUTP$62 VSS VSS sg13_lv_nmos L=0.52u W=0.15u AS=0.162p AD=0.0855p
+ PS=2.16u PD=1.14u
M$250 VSS OUTN$62 OUTP$62 VSS sg13_lv_nmos L=0.52u W=0.15u AS=0.0855p AD=0.162p
+ PS=1.14u PD=2.16u
M$251 OUTP$134 OUTN$134 VSS VSS sg13_lv_nmos L=0.52u W=0.15u AS=0.162p
+ AD=0.0855p PS=2.16u PD=1.14u
M$252 VSS OUTP$134 OUTN$134 VSS sg13_lv_nmos L=0.52u W=0.15u AS=0.0855p
+ AD=0.162p PS=1.14u PD=2.16u
M$253 OUTP$135 OUTN$135 VSS VSS sg13_lv_nmos L=0.52u W=0.15u AS=0.162p
+ AD=0.0855p PS=2.16u PD=1.14u
M$254 VSS OUTP$135 OUTN$135 VSS sg13_lv_nmos L=0.52u W=0.15u AS=0.0855p
+ AD=0.162p PS=1.14u PD=2.16u
M$255 OUTN$63 OUTP$63 VSS VSS sg13_lv_nmos L=0.52u W=0.15u AS=0.162p AD=0.0855p
+ PS=2.16u PD=1.14u
M$256 VSS OUTN$63 OUTP$63 VSS sg13_lv_nmos L=0.52u W=0.15u AS=0.0855p AD=0.162p
+ PS=1.14u PD=2.16u
M$257 OUTP$136 OUTN$136 VSS VSS sg13_lv_nmos L=0.52u W=0.15u AS=0.162p
+ AD=0.0855p PS=2.16u PD=1.14u
M$258 VSS OUTP$136 OUTN$136 VSS sg13_lv_nmos L=0.52u W=0.15u AS=0.0855p
+ AD=0.162p PS=1.14u PD=2.16u
M$259 OUTN$64 OUTP$64 VSS VSS sg13_lv_nmos L=0.52u W=0.15u AS=0.162p AD=0.0855p
+ PS=2.16u PD=1.14u
M$260 VSS OUTN$64 OUTP$64 VSS sg13_lv_nmos L=0.52u W=0.15u AS=0.0855p AD=0.162p
+ PS=1.14u PD=2.16u
M$261 OUTN$65 OUTP$65 VSS VSS sg13_lv_nmos L=0.52u W=0.15u AS=0.162p AD=0.0855p
+ PS=2.16u PD=1.14u
M$262 VSS OUTN$65 OUTP$65 VSS sg13_lv_nmos L=0.52u W=0.15u AS=0.0855p AD=0.162p
+ PS=1.14u PD=2.16u
M$263 OUTP$137 OUTN$137 VSS VSS sg13_lv_nmos L=0.52u W=0.15u AS=0.162p
+ AD=0.0855p PS=2.16u PD=1.14u
M$264 VSS OUTP$137 OUTN$137 VSS sg13_lv_nmos L=0.52u W=0.15u AS=0.0855p
+ AD=0.162p PS=1.14u PD=2.16u
M$265 OUTN$66 OUTP$66 VSS VSS sg13_lv_nmos L=0.52u W=0.15u AS=0.162p AD=0.0855p
+ PS=2.16u PD=1.14u
M$266 VSS OUTN$66 OUTP$66 VSS sg13_lv_nmos L=0.52u W=0.15u AS=0.0855p AD=0.162p
+ PS=1.14u PD=2.16u
M$267 OUTP$138 OUTN$138 VSS VSS sg13_lv_nmos L=0.52u W=0.15u AS=0.162p
+ AD=0.0855p PS=2.16u PD=1.14u
M$268 VSS OUTP$138 OUTN$138 VSS sg13_lv_nmos L=0.52u W=0.15u AS=0.0855p
+ AD=0.162p PS=1.14u PD=2.16u
M$269 OUTP$139 OUTN$139 VSS VSS sg13_lv_nmos L=0.52u W=0.15u AS=0.162p
+ AD=0.0855p PS=2.16u PD=1.14u
M$270 VSS OUTP$139 OUTN$139 VSS sg13_lv_nmos L=0.52u W=0.15u AS=0.0855p
+ AD=0.162p PS=1.14u PD=2.16u
M$271 OUTN$67 OUTP$67 VSS VSS sg13_lv_nmos L=0.52u W=0.15u AS=0.162p AD=0.0855p
+ PS=2.16u PD=1.14u
M$272 VSS OUTN$67 OUTP$67 VSS sg13_lv_nmos L=0.52u W=0.15u AS=0.0855p AD=0.162p
+ PS=1.14u PD=2.16u
M$273 OUTN$68 OUTP$68 VSS VSS sg13_lv_nmos L=0.52u W=0.15u AS=0.162p AD=0.0855p
+ PS=2.16u PD=1.14u
M$274 VSS OUTN$68 OUTP$68 VSS sg13_lv_nmos L=0.52u W=0.15u AS=0.0855p AD=0.162p
+ PS=1.14u PD=2.16u
M$275 OUTP$140 OUTN$140 VSS VSS sg13_lv_nmos L=0.52u W=0.15u AS=0.162p
+ AD=0.0855p PS=2.16u PD=1.14u
M$276 VSS OUTP$140 OUTN$140 VSS sg13_lv_nmos L=0.52u W=0.15u AS=0.0855p
+ AD=0.162p PS=1.14u PD=2.16u
M$277 OUTP$141 OUTN$141 VSS VSS sg13_lv_nmos L=0.52u W=0.15u AS=0.162p
+ AD=0.0855p PS=2.16u PD=1.14u
M$278 VSS OUTP$141 OUTN$141 VSS sg13_lv_nmos L=0.52u W=0.15u AS=0.0855p
+ AD=0.162p PS=1.14u PD=2.16u
M$279 OUTN$69 OUTP$69 VSS VSS sg13_lv_nmos L=0.52u W=0.15u AS=0.162p AD=0.0855p
+ PS=2.16u PD=1.14u
M$280 VSS OUTN$69 OUTP$69 VSS sg13_lv_nmos L=0.52u W=0.15u AS=0.0855p AD=0.162p
+ PS=1.14u PD=2.16u
M$281 OUTP$142 OUTN$142 VSS VSS sg13_lv_nmos L=0.52u W=0.15u AS=0.162p
+ AD=0.0855p PS=2.16u PD=1.14u
M$282 VSS OUTP$142 OUTN$142 VSS sg13_lv_nmos L=0.52u W=0.15u AS=0.0855p
+ AD=0.162p PS=1.14u PD=2.16u
M$283 OUTN$70 OUTP$70 VSS VSS sg13_lv_nmos L=0.52u W=0.15u AS=0.162p AD=0.0855p
+ PS=2.16u PD=1.14u
M$284 VSS OUTN$70 OUTP$70 VSS sg13_lv_nmos L=0.52u W=0.15u AS=0.0855p AD=0.162p
+ PS=1.14u PD=2.16u
M$285 OUTP$143 OUTN$143 VSS VSS sg13_lv_nmos L=0.52u W=0.15u AS=0.162p
+ AD=0.0855p PS=2.16u PD=1.14u
M$286 VSS OUTP$143 OUTN$143 VSS sg13_lv_nmos L=0.52u W=0.15u AS=0.0855p
+ AD=0.162p PS=1.14u PD=2.16u
M$287 OUTN$71 OUTP$71 VSS VSS sg13_lv_nmos L=0.52u W=0.15u AS=0.162p AD=0.0855p
+ PS=2.16u PD=1.14u
M$288 VSS OUTN$71 OUTP$71 VSS sg13_lv_nmos L=0.52u W=0.15u AS=0.0855p AD=0.162p
+ PS=1.14u PD=2.16u
M$289 OUTN EN[0]|EN[7]|INP|ON VDD VDD sg13_lv_pmos L=0.13u W=0.3u AS=0.1725p
+ AD=0.057p PS=1.75u PD=0.68u
M$290 VDD ENB[0]|ENB[7]|INN|ONB OUTP VDD sg13_lv_pmos L=0.13u W=0.3u AS=0.057p
+ AD=0.1725p PS=0.68u PD=1.75u
M$291 OUTN$1 INP|ON|ON[0]|ON[63] VDD VDD sg13_lv_pmos L=0.13u W=0.3u AS=0.1725p
+ AD=0.057p PS=1.75u PD=0.68u
M$292 VDD INN|ONB|ONB[0]|ONB[63] OUTP$1 VDD sg13_lv_pmos L=0.13u W=0.3u
+ AS=0.057p AD=0.1725p PS=0.68u PD=1.75u
M$293 OUTN$2 INP|ON|ON[1]|ON[62] VDD VDD sg13_lv_pmos L=0.13u W=0.3u AS=0.1725p
+ AD=0.057p PS=1.75u PD=0.68u
M$294 VDD INN|ONB|ONB[1]|ONB[62] OUTP$2 VDD sg13_lv_pmos L=0.13u W=0.3u
+ AS=0.057p AD=0.1725p PS=0.68u PD=1.75u
M$295 OUTN$3 INP|ON|ON[2]|ON[61] VDD VDD sg13_lv_pmos L=0.13u W=0.3u AS=0.1725p
+ AD=0.057p PS=1.75u PD=0.68u
M$296 VDD INN|ONB|ONB[2]|ONB[61] OUTP$3 VDD sg13_lv_pmos L=0.13u W=0.3u
+ AS=0.057p AD=0.1725p PS=0.68u PD=1.75u
M$297 OUTN$4 INP|ON|ON[3]|ON[60] VDD VDD sg13_lv_pmos L=0.13u W=0.3u AS=0.1725p
+ AD=0.057p PS=1.75u PD=0.68u
M$298 VDD INN|ONB|ONB[3]|ONB[60] OUTP$4 VDD sg13_lv_pmos L=0.13u W=0.3u
+ AS=0.057p AD=0.1725p PS=0.68u PD=1.75u
M$299 OUTN$5 INP|ON|ON[4]|ON[59] VDD VDD sg13_lv_pmos L=0.13u W=0.3u AS=0.1725p
+ AD=0.057p PS=1.75u PD=0.68u
M$300 VDD INN|ONB|ONB[4]|ONB[59] OUTP$5 VDD sg13_lv_pmos L=0.13u W=0.3u
+ AS=0.057p AD=0.1725p PS=0.68u PD=1.75u
M$301 OUTN$6 INP|ON|ON[58]|ON[5] VDD VDD sg13_lv_pmos L=0.13u W=0.3u AS=0.1725p
+ AD=0.057p PS=1.75u PD=0.68u
M$302 VDD INN|ONB|ONB[58]|ONB[5] OUTP$6 VDD sg13_lv_pmos L=0.13u W=0.3u
+ AS=0.057p AD=0.1725p PS=0.68u PD=1.75u
M$303 OUTN$7 INP|ON|ON[57]|ON[6] VDD VDD sg13_lv_pmos L=0.13u W=0.3u AS=0.1725p
+ AD=0.057p PS=1.75u PD=0.68u
M$304 VDD INN|ONB|ONB[57]|ONB[6] OUTP$7 VDD sg13_lv_pmos L=0.13u W=0.3u
+ AS=0.057p AD=0.1725p PS=0.68u PD=1.75u
M$305 OUTN$8 INP|ON|ON[56]|ON[7] VDD VDD sg13_lv_pmos L=0.13u W=0.3u AS=0.1725p
+ AD=0.057p PS=1.75u PD=0.68u
M$306 VDD INN|ONB|ONB[56]|ONB[7] OUTP$8 VDD sg13_lv_pmos L=0.13u W=0.3u
+ AS=0.057p AD=0.1725p PS=0.68u PD=1.75u
M$307 OUTN$9 INP|ON|ON[55]|ON[8] VDD VDD sg13_lv_pmos L=0.13u W=0.3u AS=0.1725p
+ AD=0.057p PS=1.75u PD=0.68u
M$308 VDD INN|ONB|ONB[55]|ONB[8] OUTP$9 VDD sg13_lv_pmos L=0.13u W=0.3u
+ AS=0.057p AD=0.1725p PS=0.68u PD=1.75u
M$309 OUTN$10 INP|ON|ON[54]|ON[9] VDD VDD sg13_lv_pmos L=0.13u W=0.3u
+ AS=0.1725p AD=0.057p PS=1.75u PD=0.68u
M$310 VDD INN|ONB|ONB[54]|ONB[9] OUTP$10 VDD sg13_lv_pmos L=0.13u W=0.3u
+ AS=0.057p AD=0.1725p PS=0.68u PD=1.75u
M$311 OUTN$11 INP|ON|ON[10]|ON[53] VDD VDD sg13_lv_pmos L=0.13u W=0.3u
+ AS=0.1725p AD=0.057p PS=1.75u PD=0.68u
M$312 VDD INN|ONB|ONB[10]|ONB[53] OUTP$11 VDD sg13_lv_pmos L=0.13u W=0.3u
+ AS=0.057p AD=0.1725p PS=0.68u PD=1.75u
M$313 OUTN$12 INP|ON|ON[11]|ON[52] VDD VDD sg13_lv_pmos L=0.13u W=0.3u
+ AS=0.1725p AD=0.057p PS=1.75u PD=0.68u
M$314 VDD INN|ONB|ONB[11]|ONB[52] OUTP$12 VDD sg13_lv_pmos L=0.13u W=0.3u
+ AS=0.057p AD=0.1725p PS=0.68u PD=1.75u
M$315 OUTN$13 INP|ON|ON[12]|ON[51] VDD VDD sg13_lv_pmos L=0.13u W=0.3u
+ AS=0.1725p AD=0.057p PS=1.75u PD=0.68u
M$316 VDD INN|ONB|ONB[12]|ONB[51] OUTP$13 VDD sg13_lv_pmos L=0.13u W=0.3u
+ AS=0.057p AD=0.1725p PS=0.68u PD=1.75u
M$317 OUTN$14 INP|ON|ON[13]|ON[50] VDD VDD sg13_lv_pmos L=0.13u W=0.3u
+ AS=0.1725p AD=0.057p PS=1.75u PD=0.68u
M$318 VDD INN|ONB|ONB[13]|ONB[50] OUTP$14 VDD sg13_lv_pmos L=0.13u W=0.3u
+ AS=0.057p AD=0.1725p PS=0.68u PD=1.75u
M$319 OUTN$15 INP|ON|ON[14]|ON[49] VDD VDD sg13_lv_pmos L=0.13u W=0.3u
+ AS=0.1725p AD=0.057p PS=1.75u PD=0.68u
M$320 VDD INN|ONB|ONB[14]|ONB[49] OUTP$15 VDD sg13_lv_pmos L=0.13u W=0.3u
+ AS=0.057p AD=0.1725p PS=0.68u PD=1.75u
M$321 OUTN$16 INP|ON|ON[15]|ON[48] VDD VDD sg13_lv_pmos L=0.13u W=0.3u
+ AS=0.1725p AD=0.057p PS=1.75u PD=0.68u
M$322 VDD INN|ONB|ONB[15]|ONB[48] OUTP$16 VDD sg13_lv_pmos L=0.13u W=0.3u
+ AS=0.057p AD=0.1725p PS=0.68u PD=1.75u
M$323 OUTN$17 EN[1]|EN[6]|INP|ON VDD VDD sg13_lv_pmos L=0.13u W=0.3u AS=0.1725p
+ AD=0.057p PS=1.75u PD=0.68u
M$324 VDD ENB[1]|ENB[6]|INN|ONB OUTP$17 VDD sg13_lv_pmos L=0.13u W=0.3u
+ AS=0.057p AD=0.1725p PS=0.68u PD=1.75u
M$325 OUTN$18 EN[0]|EN[5]|INP|ON VDD VDD sg13_lv_pmos L=0.13u W=0.3u AS=0.1725p
+ AD=0.057p PS=1.75u PD=0.68u
M$326 VDD ENB[0]|ENB[5]|INN|ONB OUTP$18 VDD sg13_lv_pmos L=0.13u W=0.3u
+ AS=0.057p AD=0.1725p PS=0.68u PD=1.75u
M$327 OUTN$19 INP|ON|ON[0]|ON[47] VDD VDD sg13_lv_pmos L=0.13u W=0.3u
+ AS=0.1725p AD=0.057p PS=1.75u PD=0.68u
M$328 VDD INN|ONB|ONB[0]|ONB[47] OUTP$19 VDD sg13_lv_pmos L=0.13u W=0.3u
+ AS=0.057p AD=0.1725p PS=0.68u PD=1.75u
M$329 OUTN$20 INP|ON|ON[1]|ON[46] VDD VDD sg13_lv_pmos L=0.13u W=0.3u
+ AS=0.1725p AD=0.057p PS=1.75u PD=0.68u
M$330 VDD INN|ONB|ONB[1]|ONB[46] OUTP$20 VDD sg13_lv_pmos L=0.13u W=0.3u
+ AS=0.057p AD=0.1725p PS=0.68u PD=1.75u
M$331 OUTN$21 INP|ON|ON[2]|ON[45] VDD VDD sg13_lv_pmos L=0.13u W=0.3u
+ AS=0.1725p AD=0.057p PS=1.75u PD=0.68u
M$332 VDD INN|ONB|ONB[2]|ONB[45] OUTP$21 VDD sg13_lv_pmos L=0.13u W=0.3u
+ AS=0.057p AD=0.1725p PS=0.68u PD=1.75u
M$333 OUTN$22 INP|ON|ON[3]|ON[44] VDD VDD sg13_lv_pmos L=0.13u W=0.3u
+ AS=0.1725p AD=0.057p PS=1.75u PD=0.68u
M$334 VDD INN|ONB|ONB[3]|ONB[44] OUTP$22 VDD sg13_lv_pmos L=0.13u W=0.3u
+ AS=0.057p AD=0.1725p PS=0.68u PD=1.75u
M$335 OUTN$23 INP|ON|ON[43]|ON[4] VDD VDD sg13_lv_pmos L=0.13u W=0.3u
+ AS=0.1725p AD=0.057p PS=1.75u PD=0.68u
M$336 VDD INN|ONB|ONB[43]|ONB[4] OUTP$23 VDD sg13_lv_pmos L=0.13u W=0.3u
+ AS=0.057p AD=0.1725p PS=0.68u PD=1.75u
M$337 OUTN$24 INP|ON|ON[42]|ON[5] VDD VDD sg13_lv_pmos L=0.13u W=0.3u
+ AS=0.1725p AD=0.057p PS=1.75u PD=0.68u
M$338 VDD INN|ONB|ONB[42]|ONB[5] OUTP$24 VDD sg13_lv_pmos L=0.13u W=0.3u
+ AS=0.057p AD=0.1725p PS=0.68u PD=1.75u
M$339 OUTN$25 INP|ON|ON[41]|ON[6] VDD VDD sg13_lv_pmos L=0.13u W=0.3u
+ AS=0.1725p AD=0.057p PS=1.75u PD=0.68u
M$340 VDD INN|ONB|ONB[41]|ONB[6] OUTP$25 VDD sg13_lv_pmos L=0.13u W=0.3u
+ AS=0.057p AD=0.1725p PS=0.68u PD=1.75u
M$341 OUTN$26 INP|ON|ON[40]|ON[7] VDD VDD sg13_lv_pmos L=0.13u W=0.3u
+ AS=0.1725p AD=0.057p PS=1.75u PD=0.68u
M$342 VDD INN|ONB|ONB[40]|ONB[7] OUTP$26 VDD sg13_lv_pmos L=0.13u W=0.3u
+ AS=0.057p AD=0.1725p PS=0.68u PD=1.75u
M$343 OUTN$27 INP|ON|ON[39]|ON[8] VDD VDD sg13_lv_pmos L=0.13u W=0.3u
+ AS=0.1725p AD=0.057p PS=1.75u PD=0.68u
M$344 VDD INN|ONB|ONB[39]|ONB[8] OUTP$27 VDD sg13_lv_pmos L=0.13u W=0.3u
+ AS=0.057p AD=0.1725p PS=0.68u PD=1.75u
M$345 OUTN$28 INP|ON|ON[38]|ON[9] VDD VDD sg13_lv_pmos L=0.13u W=0.3u
+ AS=0.1725p AD=0.057p PS=1.75u PD=0.68u
M$346 VDD INN|ONB|ONB[38]|ONB[9] OUTP$28 VDD sg13_lv_pmos L=0.13u W=0.3u
+ AS=0.057p AD=0.1725p PS=0.68u PD=1.75u
M$347 OUTN$29 INP|ON|ON[10]|ON[37] VDD VDD sg13_lv_pmos L=0.13u W=0.3u
+ AS=0.1725p AD=0.057p PS=1.75u PD=0.68u
M$348 VDD INN|ONB|ONB[10]|ONB[37] OUTP$29 VDD sg13_lv_pmos L=0.13u W=0.3u
+ AS=0.057p AD=0.1725p PS=0.68u PD=1.75u
M$349 OUTN$30 INP|ON|ON[11]|ON[36] VDD VDD sg13_lv_pmos L=0.13u W=0.3u
+ AS=0.1725p AD=0.057p PS=1.75u PD=0.68u
M$350 VDD INN|ONB|ONB[11]|ONB[36] OUTP$30 VDD sg13_lv_pmos L=0.13u W=0.3u
+ AS=0.057p AD=0.1725p PS=0.68u PD=1.75u
M$351 OUTN$31 INP|ON|ON[12]|ON[35] VDD VDD sg13_lv_pmos L=0.13u W=0.3u
+ AS=0.1725p AD=0.057p PS=1.75u PD=0.68u
M$352 VDD INN|ONB|ONB[12]|ONB[35] OUTP$31 VDD sg13_lv_pmos L=0.13u W=0.3u
+ AS=0.057p AD=0.1725p PS=0.68u PD=1.75u
M$353 OUTN$32 INP|ON|ON[13]|ON[34] VDD VDD sg13_lv_pmos L=0.13u W=0.3u
+ AS=0.1725p AD=0.057p PS=1.75u PD=0.68u
M$354 VDD INN|ONB|ONB[13]|ONB[34] OUTP$32 VDD sg13_lv_pmos L=0.13u W=0.3u
+ AS=0.057p AD=0.1725p PS=0.68u PD=1.75u
M$355 OUTN$33 INP|ON|ON[14]|ON[33] VDD VDD sg13_lv_pmos L=0.13u W=0.3u
+ AS=0.1725p AD=0.057p PS=1.75u PD=0.68u
M$356 VDD INN|ONB|ONB[14]|ONB[33] OUTP$33 VDD sg13_lv_pmos L=0.13u W=0.3u
+ AS=0.057p AD=0.1725p PS=0.68u PD=1.75u
M$357 OUTN$34 INP|ON|ON[15]|ON[32] VDD VDD sg13_lv_pmos L=0.13u W=0.3u
+ AS=0.1725p AD=0.057p PS=1.75u PD=0.68u
M$358 VDD INN|ONB|ONB[15]|ONB[32] OUTP$34 VDD sg13_lv_pmos L=0.13u W=0.3u
+ AS=0.057p AD=0.1725p PS=0.68u PD=1.75u
M$359 OUTN$35 EN[1]|EN[4]|INP|ON VDD VDD sg13_lv_pmos L=0.13u W=0.3u AS=0.1725p
+ AD=0.057p PS=1.75u PD=0.68u
M$360 VDD ENB[1]|ENB[4]|INN|ONB OUTP$35 VDD sg13_lv_pmos L=0.13u W=0.3u
+ AS=0.057p AD=0.1725p PS=0.68u PD=1.75u
M$361 OUTN$36 EN[0]|EN[3]|INP|ON VDD VDD sg13_lv_pmos L=0.13u W=0.3u AS=0.1725p
+ AD=0.057p PS=1.75u PD=0.68u
M$362 VDD ENB[0]|ENB[3]|INN|ONB OUTP$36 VDD sg13_lv_pmos L=0.13u W=0.3u
+ AS=0.057p AD=0.1725p PS=0.68u PD=1.75u
M$363 OUTN$37 INP|ON|ON[0]|ON[31] VDD VDD sg13_lv_pmos L=0.13u W=0.3u
+ AS=0.1725p AD=0.057p PS=1.75u PD=0.68u
M$364 VDD INN|ONB|ONB[0]|ONB[31] OUTP$37 VDD sg13_lv_pmos L=0.13u W=0.3u
+ AS=0.057p AD=0.1725p PS=0.68u PD=1.75u
M$365 OUTN$38 INP|ON|ON[1]|ON[30] VDD VDD sg13_lv_pmos L=0.13u W=0.3u
+ AS=0.1725p AD=0.057p PS=1.75u PD=0.68u
M$366 VDD INN|ONB|ONB[1]|ONB[30] OUTP$38 VDD sg13_lv_pmos L=0.13u W=0.3u
+ AS=0.057p AD=0.1725p PS=0.68u PD=1.75u
M$367 OUTN$39 INP|ON|ON[29]|ON[2] VDD VDD sg13_lv_pmos L=0.13u W=0.3u
+ AS=0.1725p AD=0.057p PS=1.75u PD=0.68u
M$368 VDD INN|ONB|ONB[29]|ONB[2] OUTP$39 VDD sg13_lv_pmos L=0.13u W=0.3u
+ AS=0.057p AD=0.1725p PS=0.68u PD=1.75u
M$369 OUTN$40 INP|ON|ON[28]|ON[3] VDD VDD sg13_lv_pmos L=0.13u W=0.3u
+ AS=0.1725p AD=0.057p PS=1.75u PD=0.68u
M$370 VDD INN|ONB|ONB[28]|ONB[3] OUTP$40 VDD sg13_lv_pmos L=0.13u W=0.3u
+ AS=0.057p AD=0.1725p PS=0.68u PD=1.75u
M$371 OUTN$41 INP|ON|ON[27]|ON[4] VDD VDD sg13_lv_pmos L=0.13u W=0.3u
+ AS=0.1725p AD=0.057p PS=1.75u PD=0.68u
M$372 VDD INN|ONB|ONB[27]|ONB[4] OUTP$41 VDD sg13_lv_pmos L=0.13u W=0.3u
+ AS=0.057p AD=0.1725p PS=0.68u PD=1.75u
M$373 OUTN$42 INP|ON|ON[26]|ON[5] VDD VDD sg13_lv_pmos L=0.13u W=0.3u
+ AS=0.1725p AD=0.057p PS=1.75u PD=0.68u
M$374 VDD INN|ONB|ONB[26]|ONB[5] OUTP$42 VDD sg13_lv_pmos L=0.13u W=0.3u
+ AS=0.057p AD=0.1725p PS=0.68u PD=1.75u
M$375 OUTN$43 INP|ON|ON[25]|ON[6] VDD VDD sg13_lv_pmos L=0.13u W=0.3u
+ AS=0.1725p AD=0.057p PS=1.75u PD=0.68u
M$376 VDD INN|ONB|ONB[25]|ONB[6] OUTP$43 VDD sg13_lv_pmos L=0.13u W=0.3u
+ AS=0.057p AD=0.1725p PS=0.68u PD=1.75u
M$377 OUTN$44 INP|ON|ON[24]|ON[7] VDD VDD sg13_lv_pmos L=0.13u W=0.3u
+ AS=0.1725p AD=0.057p PS=1.75u PD=0.68u
M$378 VDD INN|ONB|ONB[24]|ONB[7] OUTP$44 VDD sg13_lv_pmos L=0.13u W=0.3u
+ AS=0.057p AD=0.1725p PS=0.68u PD=1.75u
M$379 OUTN$45 INP|ON|ON[23]|ON[8] VDD VDD sg13_lv_pmos L=0.13u W=0.3u
+ AS=0.1725p AD=0.057p PS=1.75u PD=0.68u
M$380 VDD INN|ONB|ONB[23]|ONB[8] OUTP$45 VDD sg13_lv_pmos L=0.13u W=0.3u
+ AS=0.057p AD=0.1725p PS=0.68u PD=1.75u
M$381 OUTN$46 INP|ON|ON[22]|ON[9] VDD VDD sg13_lv_pmos L=0.13u W=0.3u
+ AS=0.1725p AD=0.057p PS=1.75u PD=0.68u
M$382 VDD INN|ONB|ONB[22]|ONB[9] OUTP$46 VDD sg13_lv_pmos L=0.13u W=0.3u
+ AS=0.057p AD=0.1725p PS=0.68u PD=1.75u
M$383 OUTN$47 INP|ON|ON[10]|ON[21] VDD VDD sg13_lv_pmos L=0.13u W=0.3u
+ AS=0.1725p AD=0.057p PS=1.75u PD=0.68u
M$384 VDD INN|ONB|ONB[10]|ONB[21] OUTP$47 VDD sg13_lv_pmos L=0.13u W=0.3u
+ AS=0.057p AD=0.1725p PS=0.68u PD=1.75u
M$385 OUTN$48 INP|ON|ON[11]|ON[20] VDD VDD sg13_lv_pmos L=0.13u W=0.3u
+ AS=0.1725p AD=0.057p PS=1.75u PD=0.68u
M$386 VDD INN|ONB|ONB[11]|ONB[20] OUTP$48 VDD sg13_lv_pmos L=0.13u W=0.3u
+ AS=0.057p AD=0.1725p PS=0.68u PD=1.75u
M$387 OUTN$49 INP|ON|ON[12]|ON[19] VDD VDD sg13_lv_pmos L=0.13u W=0.3u
+ AS=0.1725p AD=0.057p PS=1.75u PD=0.68u
M$388 VDD INN|ONB|ONB[12]|ONB[19] OUTP$49 VDD sg13_lv_pmos L=0.13u W=0.3u
+ AS=0.057p AD=0.1725p PS=0.68u PD=1.75u
M$389 OUTN$50 INP|ON|ON[13]|ON[18] VDD VDD sg13_lv_pmos L=0.13u W=0.3u
+ AS=0.1725p AD=0.057p PS=1.75u PD=0.68u
M$390 VDD INN|ONB|ONB[13]|ONB[18] OUTP$50 VDD sg13_lv_pmos L=0.13u W=0.3u
+ AS=0.057p AD=0.1725p PS=0.68u PD=1.75u
M$391 OUTN$51 INP|ON|ON[14]|ON[17] VDD VDD sg13_lv_pmos L=0.13u W=0.3u
+ AS=0.1725p AD=0.057p PS=1.75u PD=0.68u
M$392 VDD INN|ONB|ONB[14]|ONB[17] OUTP$51 VDD sg13_lv_pmos L=0.13u W=0.3u
+ AS=0.057p AD=0.1725p PS=0.68u PD=1.75u
M$393 OUTN$52 INP|ON|ON[15]|ON[16] VDD VDD sg13_lv_pmos L=0.13u W=0.3u
+ AS=0.1725p AD=0.057p PS=1.75u PD=0.68u
M$394 VDD INN|ONB|ONB[15]|ONB[16] OUTP$52 VDD sg13_lv_pmos L=0.13u W=0.3u
+ AS=0.057p AD=0.1725p PS=0.68u PD=1.75u
M$395 OUTN$53 EN[1]|EN[2]|INP|ON VDD VDD sg13_lv_pmos L=0.13u W=0.3u AS=0.1725p
+ AD=0.057p PS=1.75u PD=0.68u
M$396 VDD ENB[1]|ENB[2]|INN|ONB OUTP$53 VDD sg13_lv_pmos L=0.13u W=0.3u
+ AS=0.057p AD=0.1725p PS=0.68u PD=1.75u
M$397 OUTN$54 EN[0]|EN[1]|INP|ON VDD VDD sg13_lv_pmos L=0.13u W=0.3u AS=0.1725p
+ AD=0.057p PS=1.75u PD=0.68u
M$398 VDD ENB[0]|ENB[1]|INN|ONB OUTP$54 VDD sg13_lv_pmos L=0.13u W=0.3u
+ AS=0.057p AD=0.1725p PS=0.68u PD=1.75u
M$399 OUTN$55 INP|ON|ON[0]|ON[15] VDD VDD sg13_lv_pmos L=0.13u W=0.3u
+ AS=0.1725p AD=0.057p PS=1.75u PD=0.68u
M$400 VDD INN|ONB|ONB[0]|ONB[15] OUTP$55 VDD sg13_lv_pmos L=0.13u W=0.3u
+ AS=0.057p AD=0.1725p PS=0.68u PD=1.75u
M$401 OUTN$56 INP|ON|ON[14]|ON[1] VDD VDD sg13_lv_pmos L=0.13u W=0.3u
+ AS=0.1725p AD=0.057p PS=1.75u PD=0.68u
M$402 VDD INN|ONB|ONB[14]|ONB[1] OUTP$56 VDD sg13_lv_pmos L=0.13u W=0.3u
+ AS=0.057p AD=0.1725p PS=0.68u PD=1.75u
M$403 OUTN$57 INP|ON|ON[13]|ON[2] VDD VDD sg13_lv_pmos L=0.13u W=0.3u
+ AS=0.1725p AD=0.057p PS=1.75u PD=0.68u
M$404 VDD INN|ONB|ONB[13]|ONB[2] OUTP$57 VDD sg13_lv_pmos L=0.13u W=0.3u
+ AS=0.057p AD=0.1725p PS=0.68u PD=1.75u
M$405 OUTN$58 INP|ON|ON[12]|ON[3] VDD VDD sg13_lv_pmos L=0.13u W=0.3u
+ AS=0.1725p AD=0.057p PS=1.75u PD=0.68u
M$406 VDD INN|ONB|ONB[12]|ONB[3] OUTP$58 VDD sg13_lv_pmos L=0.13u W=0.3u
+ AS=0.057p AD=0.1725p PS=0.68u PD=1.75u
M$407 OUTN$59 INP|ON|ON[11]|ON[4] VDD VDD sg13_lv_pmos L=0.13u W=0.3u
+ AS=0.1725p AD=0.057p PS=1.75u PD=0.68u
M$408 VDD INN|ONB|ONB[11]|ONB[4] OUTP$59 VDD sg13_lv_pmos L=0.13u W=0.3u
+ AS=0.057p AD=0.1725p PS=0.68u PD=1.75u
M$409 OUTN$60 INP|ON|ON[10]|ON[5] VDD VDD sg13_lv_pmos L=0.13u W=0.3u
+ AS=0.1725p AD=0.057p PS=1.75u PD=0.68u
M$410 VDD INN|ONB|ONB[10]|ONB[5] OUTP$60 VDD sg13_lv_pmos L=0.13u W=0.3u
+ AS=0.057p AD=0.1725p PS=0.68u PD=1.75u
M$411 OUTN$61 INP|ON|ON[6]|ON[9] VDD VDD sg13_lv_pmos L=0.13u W=0.3u AS=0.1725p
+ AD=0.057p PS=1.75u PD=0.68u
M$412 VDD INN|ONB|ONB[6]|ONB[9] OUTP$61 VDD sg13_lv_pmos L=0.13u W=0.3u
+ AS=0.057p AD=0.1725p PS=0.68u PD=1.75u
M$413 OUTN$62 INP|ON|ON[7]|ON[8] VDD VDD sg13_lv_pmos L=0.13u W=0.3u AS=0.1725p
+ AD=0.057p PS=1.75u PD=0.68u
M$414 VDD INN|ONB|ONB[7]|ONB[8] OUTP$62 VDD sg13_lv_pmos L=0.13u W=0.3u
+ AS=0.057p AD=0.1725p PS=0.68u PD=1.75u
M$415 OUTN$63 INP|ON|ON[7]|ON[8]$1 VDD VDD sg13_lv_pmos L=0.13u W=0.3u
+ AS=0.1725p AD=0.057p PS=1.75u PD=0.68u
M$416 VDD INN|ONB|ONB[7]|ONB[8]$1 OUTP$63 VDD sg13_lv_pmos L=0.13u W=0.3u
+ AS=0.057p AD=0.1725p PS=0.68u PD=1.75u
M$417 OUTN$64 INP|ON|ON[6]|ON[9]$1 VDD VDD sg13_lv_pmos L=0.13u W=0.3u
+ AS=0.1725p AD=0.057p PS=1.75u PD=0.68u
M$418 VDD INN|ONB|ONB[6]|ONB[9]$1 OUTP$64 VDD sg13_lv_pmos L=0.13u W=0.3u
+ AS=0.057p AD=0.1725p PS=0.68u PD=1.75u
M$419 OUTN$65 INP|ON|ON[10]|ON[5]$1 VDD VDD sg13_lv_pmos L=0.13u W=0.3u
+ AS=0.1725p AD=0.057p PS=1.75u PD=0.68u
M$420 VDD INN|ONB|ONB[10]|ONB[5]$1 OUTP$65 VDD sg13_lv_pmos L=0.13u W=0.3u
+ AS=0.057p AD=0.1725p PS=0.68u PD=1.75u
M$421 OUTN$66 INP|ON|ON[11]|ON[4]$1 VDD VDD sg13_lv_pmos L=0.13u W=0.3u
+ AS=0.1725p AD=0.057p PS=1.75u PD=0.68u
M$422 VDD INN|ONB|ONB[11]|ONB[4]$1 OUTP$66 VDD sg13_lv_pmos L=0.13u W=0.3u
+ AS=0.057p AD=0.1725p PS=0.68u PD=1.75u
M$423 OUTN$67 INP|ON|ON[12]|ON[3]$1 VDD VDD sg13_lv_pmos L=0.13u W=0.3u
+ AS=0.1725p AD=0.057p PS=1.75u PD=0.68u
M$424 VDD INN|ONB|ONB[12]|ONB[3]$1 OUTP$67 VDD sg13_lv_pmos L=0.13u W=0.3u
+ AS=0.057p AD=0.1725p PS=0.68u PD=1.75u
M$425 OUTN$68 INP|ON|ON[13]|ON[2]$1 VDD VDD sg13_lv_pmos L=0.13u W=0.3u
+ AS=0.1725p AD=0.057p PS=1.75u PD=0.68u
M$426 VDD INN|ONB|ONB[13]|ONB[2]$1 OUTP$68 VDD sg13_lv_pmos L=0.13u W=0.3u
+ AS=0.057p AD=0.1725p PS=0.68u PD=1.75u
M$427 OUTN$69 INP|ON|ON[14]|ON[1]$1 VDD VDD sg13_lv_pmos L=0.13u W=0.3u
+ AS=0.1725p AD=0.057p PS=1.75u PD=0.68u
M$428 VDD INN|ONB|ONB[14]|ONB[1]$1 OUTP$69 VDD sg13_lv_pmos L=0.13u W=0.3u
+ AS=0.057p AD=0.1725p PS=0.68u PD=1.75u
M$429 OUTN$70 INP|ON|ON[0]|ON[15]$1 VDD VDD sg13_lv_pmos L=0.13u W=0.3u
+ AS=0.1725p AD=0.057p PS=1.75u PD=0.68u
M$430 VDD INN|ONB|ONB[0]|ONB[15]$1 OUTP$70 VDD sg13_lv_pmos L=0.13u W=0.3u
+ AS=0.057p AD=0.1725p PS=0.68u PD=1.75u
M$431 OUTN$71 EN[0]|EN[1]|INP|ON$1 VDD VDD sg13_lv_pmos L=0.13u W=0.3u
+ AS=0.1725p AD=0.057p PS=1.75u PD=0.68u
M$432 VDD ENB[0]|ENB[1]|INN|ONB$1 OUTP$71 VDD sg13_lv_pmos L=0.13u W=0.3u
+ AS=0.057p AD=0.1725p PS=0.68u PD=1.75u
M$433 C10|VbiasP[3]|VcascP|VcascP[0] OUTN VcascodeP VDD sg13_lv_pmos L=0.13u
+ W=0.3u AS=0.102p AD=0.057p PS=1.28u PD=0.68u
M$434 VcascodeP OUTP VDD VDD sg13_lv_pmos L=0.13u W=0.3u AS=0.057p AD=0.102p
+ PS=0.68u PD=1.28u
M$435 C10|VbiasP[3]|VcascP|VcascP[0] OUTN$1 VcascodeP$1 VDD sg13_lv_pmos
+ L=0.13u W=0.3u AS=0.102p AD=0.057p PS=1.28u PD=0.68u
M$436 VcascodeP$1 OUTP$1 VDD VDD sg13_lv_pmos L=0.13u W=0.3u AS=0.057p
+ AD=0.102p PS=0.68u PD=1.28u
M$437 C10|VbiasP[3]|VcascP|VcascP[0] OUTN$2 VcascodeP$2 VDD sg13_lv_pmos
+ L=0.13u W=0.3u AS=0.102p AD=0.057p PS=1.28u PD=0.68u
M$438 VcascodeP$2 OUTP$2 VDD VDD sg13_lv_pmos L=0.13u W=0.3u AS=0.057p
+ AD=0.102p PS=0.68u PD=1.28u
M$439 C10|VbiasP[3]|VcascP|VcascP[0] OUTN$3 VcascodeP$3 VDD sg13_lv_pmos
+ L=0.13u W=0.3u AS=0.102p AD=0.057p PS=1.28u PD=0.68u
M$440 VcascodeP$3 OUTP$3 VDD VDD sg13_lv_pmos L=0.13u W=0.3u AS=0.057p
+ AD=0.102p PS=0.68u PD=1.28u
M$441 C10|VbiasP[3]|VcascP|VcascP[0] OUTN$4 VcascodeP$4 VDD sg13_lv_pmos
+ L=0.13u W=0.3u AS=0.102p AD=0.057p PS=1.28u PD=0.68u
M$442 VcascodeP$4 OUTP$4 VDD VDD sg13_lv_pmos L=0.13u W=0.3u AS=0.057p
+ AD=0.102p PS=0.68u PD=1.28u
M$443 C10|VbiasP[3]|VcascP|VcascP[0] OUTN$5 VcascodeP$5 VDD sg13_lv_pmos
+ L=0.13u W=0.3u AS=0.102p AD=0.057p PS=1.28u PD=0.68u
M$444 VcascodeP$5 OUTP$5 VDD VDD sg13_lv_pmos L=0.13u W=0.3u AS=0.057p
+ AD=0.102p PS=0.68u PD=1.28u
M$445 C10|VbiasP[3]|VcascP|VcascP[0] OUTN$6 VcascodeP$6 VDD sg13_lv_pmos
+ L=0.13u W=0.3u AS=0.102p AD=0.057p PS=1.28u PD=0.68u
M$446 VcascodeP$6 OUTP$6 VDD VDD sg13_lv_pmos L=0.13u W=0.3u AS=0.057p
+ AD=0.102p PS=0.68u PD=1.28u
M$447 C10|VbiasP[3]|VcascP|VcascP[0] OUTN$7 VcascodeP$7 VDD sg13_lv_pmos
+ L=0.13u W=0.3u AS=0.102p AD=0.057p PS=1.28u PD=0.68u
M$448 VcascodeP$7 OUTP$7 VDD VDD sg13_lv_pmos L=0.13u W=0.3u AS=0.057p
+ AD=0.102p PS=0.68u PD=1.28u
M$449 C10|VbiasP[3]|VcascP|VcascP[0] OUTN$8 VcascodeP$8 VDD sg13_lv_pmos
+ L=0.13u W=0.3u AS=0.102p AD=0.057p PS=1.28u PD=0.68u
M$450 VcascodeP$8 OUTP$8 VDD VDD sg13_lv_pmos L=0.13u W=0.3u AS=0.057p
+ AD=0.102p PS=0.68u PD=1.28u
M$451 C10|VbiasP[3]|VcascP|VcascP[0] OUTN$9 VcascodeP$9 VDD sg13_lv_pmos
+ L=0.13u W=0.3u AS=0.102p AD=0.057p PS=1.28u PD=0.68u
M$452 VcascodeP$9 OUTP$9 VDD VDD sg13_lv_pmos L=0.13u W=0.3u AS=0.057p
+ AD=0.102p PS=0.68u PD=1.28u
M$453 C10|VbiasP[3]|VcascP|VcascP[0] OUTN$10 VcascodeP$10 VDD sg13_lv_pmos
+ L=0.13u W=0.3u AS=0.102p AD=0.057p PS=1.28u PD=0.68u
M$454 VcascodeP$10 OUTP$10 VDD VDD sg13_lv_pmos L=0.13u W=0.3u AS=0.057p
+ AD=0.102p PS=0.68u PD=1.28u
M$455 C10|VbiasP[3]|VcascP|VcascP[0] OUTN$11 VcascodeP$11 VDD sg13_lv_pmos
+ L=0.13u W=0.3u AS=0.102p AD=0.057p PS=1.28u PD=0.68u
M$456 VcascodeP$11 OUTP$11 VDD VDD sg13_lv_pmos L=0.13u W=0.3u AS=0.057p
+ AD=0.102p PS=0.68u PD=1.28u
M$457 C10|VbiasP[3]|VcascP|VcascP[0] OUTN$12 VcascodeP$12 VDD sg13_lv_pmos
+ L=0.13u W=0.3u AS=0.102p AD=0.057p PS=1.28u PD=0.68u
M$458 VcascodeP$12 OUTP$12 VDD VDD sg13_lv_pmos L=0.13u W=0.3u AS=0.057p
+ AD=0.102p PS=0.68u PD=1.28u
M$459 C10|VbiasP[3]|VcascP|VcascP[0] OUTN$13 VcascodeP$13 VDD sg13_lv_pmos
+ L=0.13u W=0.3u AS=0.102p AD=0.057p PS=1.28u PD=0.68u
M$460 VcascodeP$13 OUTP$13 VDD VDD sg13_lv_pmos L=0.13u W=0.3u AS=0.057p
+ AD=0.102p PS=0.68u PD=1.28u
M$461 C10|VbiasP[3]|VcascP|VcascP[0] OUTN$14 VcascodeP$14 VDD sg13_lv_pmos
+ L=0.13u W=0.3u AS=0.102p AD=0.057p PS=1.28u PD=0.68u
M$462 VcascodeP$14 OUTP$14 VDD VDD sg13_lv_pmos L=0.13u W=0.3u AS=0.057p
+ AD=0.102p PS=0.68u PD=1.28u
M$463 C10|VbiasP[3]|VcascP|VcascP[0] OUTN$15 VcascodeP$15 VDD sg13_lv_pmos
+ L=0.13u W=0.3u AS=0.102p AD=0.057p PS=1.28u PD=0.68u
M$464 VcascodeP$15 OUTP$15 VDD VDD sg13_lv_pmos L=0.13u W=0.3u AS=0.057p
+ AD=0.102p PS=0.68u PD=1.28u
M$465 C10|VbiasP[3]|VcascP|VcascP[0] OUTN$16 VcascodeP$16 VDD sg13_lv_pmos
+ L=0.13u W=0.3u AS=0.102p AD=0.057p PS=1.28u PD=0.68u
M$466 VcascodeP$16 OUTP$16 VDD VDD sg13_lv_pmos L=0.13u W=0.3u AS=0.057p
+ AD=0.102p PS=0.68u PD=1.28u
M$467 C10|VbiasP[3]|VcascP|VcascP[0] OUTN$17 VcascodeP$17 VDD sg13_lv_pmos
+ L=0.13u W=0.3u AS=0.102p AD=0.057p PS=1.28u PD=0.68u
M$468 VcascodeP$17 OUTP$17 VDD VDD sg13_lv_pmos L=0.13u W=0.3u AS=0.057p
+ AD=0.102p PS=0.68u PD=1.28u
M$469 C10|C30|VbiasP[2]|VcascP|VcascP[0] OUTN$18 VcascodeP$18 VDD sg13_lv_pmos
+ L=0.13u W=0.3u AS=0.102p AD=0.057p PS=1.28u PD=0.68u
M$470 VcascodeP$18 OUTP$18 VDD VDD sg13_lv_pmos L=0.13u W=0.3u AS=0.057p
+ AD=0.102p PS=0.68u PD=1.28u
M$471 C10|C30|VbiasP[2]|VcascP|VcascP[0] OUTN$19 VcascodeP$19 VDD sg13_lv_pmos
+ L=0.13u W=0.3u AS=0.102p AD=0.057p PS=1.28u PD=0.68u
M$472 VcascodeP$19 OUTP$19 VDD VDD sg13_lv_pmos L=0.13u W=0.3u AS=0.057p
+ AD=0.102p PS=0.68u PD=1.28u
M$473 C10|C30|VbiasP[2]|VcascP|VcascP[0] OUTN$20 VcascodeP$20 VDD sg13_lv_pmos
+ L=0.13u W=0.3u AS=0.102p AD=0.057p PS=1.28u PD=0.68u
M$474 VcascodeP$20 OUTP$20 VDD VDD sg13_lv_pmos L=0.13u W=0.3u AS=0.057p
+ AD=0.102p PS=0.68u PD=1.28u
M$475 C10|C30|VbiasP[2]|VcascP|VcascP[0] OUTN$21 VcascodeP$21 VDD sg13_lv_pmos
+ L=0.13u W=0.3u AS=0.102p AD=0.057p PS=1.28u PD=0.68u
M$476 VcascodeP$21 OUTP$21 VDD VDD sg13_lv_pmos L=0.13u W=0.3u AS=0.057p
+ AD=0.102p PS=0.68u PD=1.28u
M$477 C10|C30|VbiasP[2]|VcascP|VcascP[0] OUTN$22 VcascodeP$22 VDD sg13_lv_pmos
+ L=0.13u W=0.3u AS=0.102p AD=0.057p PS=1.28u PD=0.68u
M$478 VcascodeP$22 OUTP$22 VDD VDD sg13_lv_pmos L=0.13u W=0.3u AS=0.057p
+ AD=0.102p PS=0.68u PD=1.28u
M$479 C10|C30|VbiasP[2]|VcascP|VcascP[0] OUTN$23 VcascodeP$23 VDD sg13_lv_pmos
+ L=0.13u W=0.3u AS=0.102p AD=0.057p PS=1.28u PD=0.68u
M$480 VcascodeP$23 OUTP$23 VDD VDD sg13_lv_pmos L=0.13u W=0.3u AS=0.057p
+ AD=0.102p PS=0.68u PD=1.28u
M$481 C10|C30|VbiasP[2]|VcascP|VcascP[0] OUTN$24 VcascodeP$24 VDD sg13_lv_pmos
+ L=0.13u W=0.3u AS=0.102p AD=0.057p PS=1.28u PD=0.68u
M$482 VcascodeP$24 OUTP$24 VDD VDD sg13_lv_pmos L=0.13u W=0.3u AS=0.057p
+ AD=0.102p PS=0.68u PD=1.28u
M$483 C10|C30|VbiasP[2]|VcascP|VcascP[0] OUTN$25 VcascodeP$25 VDD sg13_lv_pmos
+ L=0.13u W=0.3u AS=0.102p AD=0.057p PS=1.28u PD=0.68u
M$484 VcascodeP$25 OUTP$25 VDD VDD sg13_lv_pmos L=0.13u W=0.3u AS=0.057p
+ AD=0.102p PS=0.68u PD=1.28u
M$485 C10|C30|VbiasP[2]|VcascP|VcascP[0] OUTN$26 VcascodeP$26 VDD sg13_lv_pmos
+ L=0.13u W=0.3u AS=0.102p AD=0.057p PS=1.28u PD=0.68u
M$486 VcascodeP$26 OUTP$26 VDD VDD sg13_lv_pmos L=0.13u W=0.3u AS=0.057p
+ AD=0.102p PS=0.68u PD=1.28u
M$487 C10|C30|VbiasP[2]|VcascP|VcascP[0] OUTN$27 VcascodeP$27 VDD sg13_lv_pmos
+ L=0.13u W=0.3u AS=0.102p AD=0.057p PS=1.28u PD=0.68u
M$488 VcascodeP$27 OUTP$27 VDD VDD sg13_lv_pmos L=0.13u W=0.3u AS=0.057p
+ AD=0.102p PS=0.68u PD=1.28u
M$489 C10|C30|VbiasP[2]|VcascP|VcascP[0] OUTN$28 VcascodeP$28 VDD sg13_lv_pmos
+ L=0.13u W=0.3u AS=0.102p AD=0.057p PS=1.28u PD=0.68u
M$490 VcascodeP$28 OUTP$28 VDD VDD sg13_lv_pmos L=0.13u W=0.3u AS=0.057p
+ AD=0.102p PS=0.68u PD=1.28u
M$491 C10|C30|VbiasP[2]|VcascP|VcascP[0] OUTN$29 VcascodeP$29 VDD sg13_lv_pmos
+ L=0.13u W=0.3u AS=0.102p AD=0.057p PS=1.28u PD=0.68u
M$492 VcascodeP$29 OUTP$29 VDD VDD sg13_lv_pmos L=0.13u W=0.3u AS=0.057p
+ AD=0.102p PS=0.68u PD=1.28u
M$493 C10|C30|VbiasP[2]|VcascP|VcascP[0] OUTN$30 VcascodeP$30 VDD sg13_lv_pmos
+ L=0.13u W=0.3u AS=0.102p AD=0.057p PS=1.28u PD=0.68u
M$494 VcascodeP$30 OUTP$30 VDD VDD sg13_lv_pmos L=0.13u W=0.3u AS=0.057p
+ AD=0.102p PS=0.68u PD=1.28u
M$495 C10|C30|VbiasP[2]|VcascP|VcascP[0] OUTN$31 VcascodeP$31 VDD sg13_lv_pmos
+ L=0.13u W=0.3u AS=0.102p AD=0.057p PS=1.28u PD=0.68u
M$496 VcascodeP$31 OUTP$31 VDD VDD sg13_lv_pmos L=0.13u W=0.3u AS=0.057p
+ AD=0.102p PS=0.68u PD=1.28u
M$497 C10|C30|VbiasP[2]|VcascP|VcascP[0] OUTN$32 VcascodeP$32 VDD sg13_lv_pmos
+ L=0.13u W=0.3u AS=0.102p AD=0.057p PS=1.28u PD=0.68u
M$498 VcascodeP$32 OUTP$32 VDD VDD sg13_lv_pmos L=0.13u W=0.3u AS=0.057p
+ AD=0.102p PS=0.68u PD=1.28u
M$499 C10|C30|VbiasP[2]|VcascP|VcascP[0] OUTN$33 VcascodeP$33 VDD sg13_lv_pmos
+ L=0.13u W=0.3u AS=0.102p AD=0.057p PS=1.28u PD=0.68u
M$500 VcascodeP$33 OUTP$33 VDD VDD sg13_lv_pmos L=0.13u W=0.3u AS=0.057p
+ AD=0.102p PS=0.68u PD=1.28u
M$501 C10|C30|VbiasP[2]|VcascP|VcascP[0] OUTN$34 VcascodeP$34 VDD sg13_lv_pmos
+ L=0.13u W=0.3u AS=0.102p AD=0.057p PS=1.28u PD=0.68u
M$502 VcascodeP$34 OUTP$34 VDD VDD sg13_lv_pmos L=0.13u W=0.3u AS=0.057p
+ AD=0.102p PS=0.68u PD=1.28u
M$503 C10|C30|VbiasP[2]|VcascP|VcascP[0] OUTN$35 VcascodeP$35 VDD sg13_lv_pmos
+ L=0.13u W=0.3u AS=0.102p AD=0.057p PS=1.28u PD=0.68u
M$504 VcascodeP$35 OUTP$35 VDD VDD sg13_lv_pmos L=0.13u W=0.3u AS=0.057p
+ AD=0.102p PS=0.68u PD=1.28u
M$505 C10|C30|VbiasP[1]|VcascP|VcascP[0] OUTN$36 VcascodeP$36 VDD sg13_lv_pmos
+ L=0.13u W=0.3u AS=0.102p AD=0.057p PS=1.28u PD=0.68u
M$506 VcascodeP$36 OUTP$36 VDD VDD sg13_lv_pmos L=0.13u W=0.3u AS=0.057p
+ AD=0.102p PS=0.68u PD=1.28u
M$507 C10|C30|VbiasP[1]|VcascP|VcascP[0] OUTN$37 VcascodeP$37 VDD sg13_lv_pmos
+ L=0.13u W=0.3u AS=0.102p AD=0.057p PS=1.28u PD=0.68u
M$508 VcascodeP$37 OUTP$37 VDD VDD sg13_lv_pmos L=0.13u W=0.3u AS=0.057p
+ AD=0.102p PS=0.68u PD=1.28u
M$509 C10|C30|VbiasP[1]|VcascP|VcascP[0] OUTN$38 VcascodeP$38 VDD sg13_lv_pmos
+ L=0.13u W=0.3u AS=0.102p AD=0.057p PS=1.28u PD=0.68u
M$510 VcascodeP$38 OUTP$38 VDD VDD sg13_lv_pmos L=0.13u W=0.3u AS=0.057p
+ AD=0.102p PS=0.68u PD=1.28u
M$511 C10|C30|VbiasP[1]|VcascP|VcascP[0] OUTN$39 VcascodeP$39 VDD sg13_lv_pmos
+ L=0.13u W=0.3u AS=0.102p AD=0.057p PS=1.28u PD=0.68u
M$512 VcascodeP$39 OUTP$39 VDD VDD sg13_lv_pmos L=0.13u W=0.3u AS=0.057p
+ AD=0.102p PS=0.68u PD=1.28u
M$513 C10|C30|VbiasP[1]|VcascP|VcascP[0] OUTN$40 VcascodeP$40 VDD sg13_lv_pmos
+ L=0.13u W=0.3u AS=0.102p AD=0.057p PS=1.28u PD=0.68u
M$514 VcascodeP$40 OUTP$40 VDD VDD sg13_lv_pmos L=0.13u W=0.3u AS=0.057p
+ AD=0.102p PS=0.68u PD=1.28u
M$515 C10|C30|VbiasP[1]|VcascP|VcascP[0] OUTN$41 VcascodeP$41 VDD sg13_lv_pmos
+ L=0.13u W=0.3u AS=0.102p AD=0.057p PS=1.28u PD=0.68u
M$516 VcascodeP$41 OUTP$41 VDD VDD sg13_lv_pmos L=0.13u W=0.3u AS=0.057p
+ AD=0.102p PS=0.68u PD=1.28u
M$517 C10|C30|VbiasP[1]|VcascP|VcascP[0] OUTN$42 VcascodeP$42 VDD sg13_lv_pmos
+ L=0.13u W=0.3u AS=0.102p AD=0.057p PS=1.28u PD=0.68u
M$518 VcascodeP$42 OUTP$42 VDD VDD sg13_lv_pmos L=0.13u W=0.3u AS=0.057p
+ AD=0.102p PS=0.68u PD=1.28u
M$519 C10|C30|VbiasP[1]|VcascP|VcascP[0] OUTN$43 VcascodeP$43 VDD sg13_lv_pmos
+ L=0.13u W=0.3u AS=0.102p AD=0.057p PS=1.28u PD=0.68u
M$520 VcascodeP$43 OUTP$43 VDD VDD sg13_lv_pmos L=0.13u W=0.3u AS=0.057p
+ AD=0.102p PS=0.68u PD=1.28u
M$521 C10|C30|VbiasP[1]|VcascP|VcascP[0] OUTN$44 VcascodeP$44 VDD sg13_lv_pmos
+ L=0.13u W=0.3u AS=0.102p AD=0.057p PS=1.28u PD=0.68u
M$522 VcascodeP$44 OUTP$44 VDD VDD sg13_lv_pmos L=0.13u W=0.3u AS=0.057p
+ AD=0.102p PS=0.68u PD=1.28u
M$523 C10|C30|VbiasP[1]|VcascP|VcascP[0] OUTN$45 VcascodeP$45 VDD sg13_lv_pmos
+ L=0.13u W=0.3u AS=0.102p AD=0.057p PS=1.28u PD=0.68u
M$524 VcascodeP$45 OUTP$45 VDD VDD sg13_lv_pmos L=0.13u W=0.3u AS=0.057p
+ AD=0.102p PS=0.68u PD=1.28u
M$525 C10|C30|VbiasP[1]|VcascP|VcascP[0] OUTN$46 VcascodeP$46 VDD sg13_lv_pmos
+ L=0.13u W=0.3u AS=0.102p AD=0.057p PS=1.28u PD=0.68u
M$526 VcascodeP$46 OUTP$46 VDD VDD sg13_lv_pmos L=0.13u W=0.3u AS=0.057p
+ AD=0.102p PS=0.68u PD=1.28u
M$527 C10|C30|VbiasP[1]|VcascP|VcascP[0] OUTN$47 VcascodeP$47 VDD sg13_lv_pmos
+ L=0.13u W=0.3u AS=0.102p AD=0.057p PS=1.28u PD=0.68u
M$528 VcascodeP$47 OUTP$47 VDD VDD sg13_lv_pmos L=0.13u W=0.3u AS=0.057p
+ AD=0.102p PS=0.68u PD=1.28u
M$529 C10|C30|VbiasP[1]|VcascP|VcascP[0] OUTN$48 VcascodeP$48 VDD sg13_lv_pmos
+ L=0.13u W=0.3u AS=0.102p AD=0.057p PS=1.28u PD=0.68u
M$530 VcascodeP$48 OUTP$48 VDD VDD sg13_lv_pmos L=0.13u W=0.3u AS=0.057p
+ AD=0.102p PS=0.68u PD=1.28u
M$531 C10|C30|VbiasP[1]|VcascP|VcascP[0] OUTN$49 VcascodeP$49 VDD sg13_lv_pmos
+ L=0.13u W=0.3u AS=0.102p AD=0.057p PS=1.28u PD=0.68u
M$532 VcascodeP$49 OUTP$49 VDD VDD sg13_lv_pmos L=0.13u W=0.3u AS=0.057p
+ AD=0.102p PS=0.68u PD=1.28u
M$533 C10|C30|VbiasP[1]|VcascP|VcascP[0] OUTN$50 VcascodeP$50 VDD sg13_lv_pmos
+ L=0.13u W=0.3u AS=0.102p AD=0.057p PS=1.28u PD=0.68u
M$534 VcascodeP$50 OUTP$50 VDD VDD sg13_lv_pmos L=0.13u W=0.3u AS=0.057p
+ AD=0.102p PS=0.68u PD=1.28u
M$535 C10|C30|VbiasP[1]|VcascP|VcascP[0] OUTN$51 VcascodeP$51 VDD sg13_lv_pmos
+ L=0.13u W=0.3u AS=0.102p AD=0.057p PS=1.28u PD=0.68u
M$536 VcascodeP$51 OUTP$51 VDD VDD sg13_lv_pmos L=0.13u W=0.3u AS=0.057p
+ AD=0.102p PS=0.68u PD=1.28u
M$537 C10|C30|VbiasP[1]|VcascP|VcascP[0] OUTN$52 VcascodeP$52 VDD sg13_lv_pmos
+ L=0.13u W=0.3u AS=0.102p AD=0.057p PS=1.28u PD=0.68u
M$538 VcascodeP$52 OUTP$52 VDD VDD sg13_lv_pmos L=0.13u W=0.3u AS=0.057p
+ AD=0.102p PS=0.68u PD=1.28u
M$539 C10|C30|VbiasP[1]|VcascP|VcascP[0] OUTN$53 VcascodeP$53 VDD sg13_lv_pmos
+ L=0.13u W=0.3u AS=0.102p AD=0.057p PS=1.28u PD=0.68u
M$540 VcascodeP$53 OUTP$53 VDD VDD sg13_lv_pmos L=0.13u W=0.3u AS=0.057p
+ AD=0.102p PS=0.68u PD=1.28u
M$541 C10|C30|VbiasP[0]|VcascP|VcascP[0] OUTN$54 VcascodeP$54 VDD sg13_lv_pmos
+ L=0.13u W=0.3u AS=0.102p AD=0.057p PS=1.28u PD=0.68u
M$542 VcascodeP$54 OUTP$54 VDD VDD sg13_lv_pmos L=0.13u W=0.3u AS=0.057p
+ AD=0.102p PS=0.68u PD=1.28u
M$543 C10|C30|VbiasP[0]|VcascP|VcascP[0] OUTN$55 VcascodeP$55 VDD sg13_lv_pmos
+ L=0.13u W=0.3u AS=0.102p AD=0.057p PS=1.28u PD=0.68u
M$544 VcascodeP$55 OUTP$55 VDD VDD sg13_lv_pmos L=0.13u W=0.3u AS=0.057p
+ AD=0.102p PS=0.68u PD=1.28u
M$545 C10|C30|VbiasP[0]|VcascP|VcascP[0] OUTN$56 VcascodeP$56 VDD sg13_lv_pmos
+ L=0.13u W=0.3u AS=0.102p AD=0.057p PS=1.28u PD=0.68u
M$546 VcascodeP$56 OUTP$56 VDD VDD sg13_lv_pmos L=0.13u W=0.3u AS=0.057p
+ AD=0.102p PS=0.68u PD=1.28u
M$547 C10|C30|VbiasP[0]|VcascP|VcascP[0] OUTN$57 VcascodeP$57 VDD sg13_lv_pmos
+ L=0.13u W=0.3u AS=0.102p AD=0.057p PS=1.28u PD=0.68u
M$548 VcascodeP$57 OUTP$57 VDD VDD sg13_lv_pmos L=0.13u W=0.3u AS=0.057p
+ AD=0.102p PS=0.68u PD=1.28u
M$549 C10|C30|VbiasP[0]|VcascP|VcascP[0] OUTN$58 VcascodeP$58 VDD sg13_lv_pmos
+ L=0.13u W=0.3u AS=0.102p AD=0.057p PS=1.28u PD=0.68u
M$550 VcascodeP$58 OUTP$58 VDD VDD sg13_lv_pmos L=0.13u W=0.3u AS=0.057p
+ AD=0.102p PS=0.68u PD=1.28u
M$551 C10|C30|VbiasP[0]|VcascP|VcascP[0] OUTN$59 VcascodeP$59 VDD sg13_lv_pmos
+ L=0.13u W=0.3u AS=0.102p AD=0.057p PS=1.28u PD=0.68u
M$552 VcascodeP$59 OUTP$59 VDD VDD sg13_lv_pmos L=0.13u W=0.3u AS=0.057p
+ AD=0.102p PS=0.68u PD=1.28u
M$553 C10|C30|VbiasP[0]|VcascP|VcascP[0] OUTN$60 VcascodeP$60 VDD sg13_lv_pmos
+ L=0.13u W=0.3u AS=0.102p AD=0.057p PS=1.28u PD=0.68u
M$554 VcascodeP$60 OUTP$60 VDD VDD sg13_lv_pmos L=0.13u W=0.3u AS=0.057p
+ AD=0.102p PS=0.68u PD=1.28u
M$555 C10|C30|VbiasP[0]|VcascP|VcascP[0] OUTN$61 VcascodeP$61 VDD sg13_lv_pmos
+ L=0.13u W=0.3u AS=0.102p AD=0.057p PS=1.28u PD=0.68u
M$556 VcascodeP$61 OUTP$61 VDD VDD sg13_lv_pmos L=0.13u W=0.3u AS=0.057p
+ AD=0.102p PS=0.68u PD=1.28u
M$557 C10|C30|VbiasP[0]|VcascP|VcascP[0] OUTN$62 VcascodeP$62 VDD sg13_lv_pmos
+ L=0.13u W=0.3u AS=0.102p AD=0.057p PS=1.28u PD=0.68u
M$558 VcascodeP$62 OUTP$62 VDD VDD sg13_lv_pmos L=0.13u W=0.3u AS=0.057p
+ AD=0.102p PS=0.68u PD=1.28u
M$559 C10|C30|VbiasP[0]|VcascP|VcascP[0] OUTN$63 VcascodeP$63 VDD sg13_lv_pmos
+ L=0.13u W=0.3u AS=0.102p AD=0.057p PS=1.28u PD=0.68u
M$560 VcascodeP$63 OUTP$63 VDD VDD sg13_lv_pmos L=0.13u W=0.3u AS=0.057p
+ AD=0.102p PS=0.68u PD=1.28u
M$561 C10|C30|VbiasP[0]|VcascP|VcascP[0] OUTN$64 VcascodeP$64 VDD sg13_lv_pmos
+ L=0.13u W=0.3u AS=0.102p AD=0.057p PS=1.28u PD=0.68u
M$562 VcascodeP$64 OUTP$64 VDD VDD sg13_lv_pmos L=0.13u W=0.3u AS=0.057p
+ AD=0.102p PS=0.68u PD=1.28u
M$563 C10|C30|VbiasP[0]|VcascP|VcascP[0] OUTN$65 VcascodeP$65 VDD sg13_lv_pmos
+ L=0.13u W=0.3u AS=0.102p AD=0.057p PS=1.28u PD=0.68u
M$564 VcascodeP$65 OUTP$65 VDD VDD sg13_lv_pmos L=0.13u W=0.3u AS=0.057p
+ AD=0.102p PS=0.68u PD=1.28u
M$565 C10|C30|VbiasP[0]|VcascP|VcascP[0] OUTN$66 VcascodeP$66 VDD sg13_lv_pmos
+ L=0.13u W=0.3u AS=0.102p AD=0.057p PS=1.28u PD=0.68u
M$566 VcascodeP$66 OUTP$66 VDD VDD sg13_lv_pmos L=0.13u W=0.3u AS=0.057p
+ AD=0.102p PS=0.68u PD=1.28u
M$567 C10|C30|VbiasP[0]|VcascP|VcascP[0] OUTN$67 VcascodeP$67 VDD sg13_lv_pmos
+ L=0.13u W=0.3u AS=0.102p AD=0.057p PS=1.28u PD=0.68u
M$568 VcascodeP$67 OUTP$67 VDD VDD sg13_lv_pmos L=0.13u W=0.3u AS=0.057p
+ AD=0.102p PS=0.68u PD=1.28u
M$569 C10|C30|VbiasP[0]|VcascP|VcascP[0] OUTN$68 VcascodeP$68 VDD sg13_lv_pmos
+ L=0.13u W=0.3u AS=0.102p AD=0.057p PS=1.28u PD=0.68u
M$570 VcascodeP$68 OUTP$68 VDD VDD sg13_lv_pmos L=0.13u W=0.3u AS=0.057p
+ AD=0.102p PS=0.68u PD=1.28u
M$571 C10|C30|VbiasP[0]|VcascP|VcascP[0] OUTN$69 VcascodeP$69 VDD sg13_lv_pmos
+ L=0.13u W=0.3u AS=0.102p AD=0.057p PS=1.28u PD=0.68u
M$572 VcascodeP$69 OUTP$69 VDD VDD sg13_lv_pmos L=0.13u W=0.3u AS=0.057p
+ AD=0.102p PS=0.68u PD=1.28u
M$573 C10|C30|VbiasP[0]|VcascP|VcascP[0] OUTN$70 VcascodeP$70 VDD sg13_lv_pmos
+ L=0.13u W=0.3u AS=0.102p AD=0.057p PS=1.28u PD=0.68u
M$574 VcascodeP$70 OUTP$70 VDD VDD sg13_lv_pmos L=0.13u W=0.3u AS=0.057p
+ AD=0.102p PS=0.68u PD=1.28u
M$575 C10|C30|VbiasP[0]|VcascP|VcascP[0] OUTN$71 VcascodeP$71 VDD sg13_lv_pmos
+ L=0.13u W=0.3u AS=0.102p AD=0.057p PS=1.28u PD=0.68u
M$576 VcascodeP$71 OUTP$71 VDD VDD sg13_lv_pmos L=0.13u W=0.3u AS=0.057p
+ AD=0.102p PS=0.68u PD=1.28u
M$577 C10|VbiasP[3]|VcascP|VcascP[0] C10|VbiasP[3]|VcascP|VcascP[0]
+ C11|Iout|VbiasP|VbiasP[0] VDD sg13_lv_pmos L=0.15u W=11.7u AS=3.978p
+ AD=3.978p PS=24.76u PD=24.76u
M$578 VDD C11|Iout|VbiasP|VbiasP[0] \$372 VDD sg13_lv_pmos L=5u W=1.45u
+ AS=0.493p AD=0.20875p PS=3.58u PD=1.75u
M$579 \$372 VcascodeP C11|Iout|VbiasP|VbiasP[0] VDD sg13_lv_pmos L=0.6u W=1.2u
+ AS=0.20875p AD=0.516p PS=1.75u PD=3.26u
M$580 VDD C11|Iout|VbiasP|VbiasP[0] \$374 VDD sg13_lv_pmos L=5u W=1.45u
+ AS=0.493p AD=0.20875p PS=3.58u PD=1.75u
M$581 \$374 VcascodeP$1 Iout VDD sg13_lv_pmos L=0.6u W=1.2u AS=0.20875p
+ AD=0.516p PS=1.75u PD=3.26u
M$582 VDD C11|Iout|VbiasP|VbiasP[0] \$376 VDD sg13_lv_pmos L=5u W=1.45u
+ AS=0.493p AD=0.20875p PS=3.58u PD=1.75u
M$583 \$376 VcascodeP$2 Iout VDD sg13_lv_pmos L=0.6u W=1.2u AS=0.20875p
+ AD=0.516p PS=1.75u PD=3.26u
M$584 VDD C11|Iout|VbiasP|VbiasP[0] \$377 VDD sg13_lv_pmos L=5u W=1.45u
+ AS=0.493p AD=0.20875p PS=3.58u PD=1.75u
M$585 \$377 VcascodeP$3 Iout VDD sg13_lv_pmos L=0.6u W=1.2u AS=0.20875p
+ AD=0.516p PS=1.75u PD=3.26u
M$586 VDD C11|Iout|VbiasP|VbiasP[0] \$378 VDD sg13_lv_pmos L=5u W=1.45u
+ AS=0.493p AD=0.20875p PS=3.58u PD=1.75u
M$587 \$378 VcascodeP$4 Iout VDD sg13_lv_pmos L=0.6u W=1.2u AS=0.20875p
+ AD=0.516p PS=1.75u PD=3.26u
M$588 VDD C11|Iout|VbiasP|VbiasP[0] \$380 VDD sg13_lv_pmos L=5u W=1.45u
+ AS=0.493p AD=0.20875p PS=3.58u PD=1.75u
M$589 \$380 VcascodeP$5 Iout VDD sg13_lv_pmos L=0.6u W=1.2u AS=0.20875p
+ AD=0.516p PS=1.75u PD=3.26u
M$590 VDD C11|Iout|VbiasP|VbiasP[0] \$384 VDD sg13_lv_pmos L=5u W=1.45u
+ AS=0.493p AD=0.20875p PS=3.58u PD=1.75u
M$591 \$384 VcascodeP$6 Iout VDD sg13_lv_pmos L=0.6u W=1.2u AS=0.20875p
+ AD=0.516p PS=1.75u PD=3.26u
M$592 VDD C11|Iout|VbiasP|VbiasP[0] \$382 VDD sg13_lv_pmos L=5u W=1.45u
+ AS=0.493p AD=0.20875p PS=3.58u PD=1.75u
M$593 \$382 VcascodeP$7 Iout VDD sg13_lv_pmos L=0.6u W=1.2u AS=0.20875p
+ AD=0.516p PS=1.75u PD=3.26u
M$594 VDD C11|Iout|VbiasP|VbiasP[0] \$386 VDD sg13_lv_pmos L=5u W=1.45u
+ AS=0.493p AD=0.20875p PS=3.58u PD=1.75u
M$595 \$386 VcascodeP$8 Iout VDD sg13_lv_pmos L=0.6u W=1.2u AS=0.20875p
+ AD=0.516p PS=1.75u PD=3.26u
M$596 VDD C11|Iout|VbiasP|VbiasP[0] \$387 VDD sg13_lv_pmos L=5u W=1.45u
+ AS=0.493p AD=0.20875p PS=3.58u PD=1.75u
M$597 \$387 VcascodeP$9 Iout VDD sg13_lv_pmos L=0.6u W=1.2u AS=0.20875p
+ AD=0.516p PS=1.75u PD=3.26u
M$598 VDD C11|Iout|VbiasP|VbiasP[0] \$391 VDD sg13_lv_pmos L=5u W=1.45u
+ AS=0.493p AD=0.20875p PS=3.58u PD=1.75u
M$599 \$391 VcascodeP$10 Iout VDD sg13_lv_pmos L=0.6u W=1.2u AS=0.20875p
+ AD=0.516p PS=1.75u PD=3.26u
M$600 VDD C11|Iout|VbiasP|VbiasP[0] \$389 VDD sg13_lv_pmos L=5u W=1.45u
+ AS=0.493p AD=0.20875p PS=3.58u PD=1.75u
M$601 \$389 VcascodeP$11 Iout VDD sg13_lv_pmos L=0.6u W=1.2u AS=0.20875p
+ AD=0.516p PS=1.75u PD=3.26u
M$602 VDD C11|Iout|VbiasP|VbiasP[0] \$393 VDD sg13_lv_pmos L=5u W=1.45u
+ AS=0.493p AD=0.20875p PS=3.58u PD=1.75u
M$603 \$393 VcascodeP$12 Iout VDD sg13_lv_pmos L=0.6u W=1.2u AS=0.20875p
+ AD=0.516p PS=1.75u PD=3.26u
M$604 VDD C11|Iout|VbiasP|VbiasP[0] \$394 VDD sg13_lv_pmos L=5u W=1.45u
+ AS=0.493p AD=0.20875p PS=3.58u PD=1.75u
M$605 \$394 VcascodeP$13 Iout VDD sg13_lv_pmos L=0.6u W=1.2u AS=0.20875p
+ AD=0.516p PS=1.75u PD=3.26u
M$606 VDD C11|Iout|VbiasP|VbiasP[0] \$396 VDD sg13_lv_pmos L=5u W=1.45u
+ AS=0.493p AD=0.20875p PS=3.58u PD=1.75u
M$607 \$396 VcascodeP$14 Iout VDD sg13_lv_pmos L=0.6u W=1.2u AS=0.20875p
+ AD=0.516p PS=1.75u PD=3.26u
M$608 VDD C11|Iout|VbiasP|VbiasP[0] \$399 VDD sg13_lv_pmos L=5u W=1.45u
+ AS=0.493p AD=0.20875p PS=3.58u PD=1.75u
M$609 \$399 VcascodeP$15 Iout VDD sg13_lv_pmos L=0.6u W=1.2u AS=0.20875p
+ AD=0.516p PS=1.75u PD=3.26u
M$610 VDD C11|Iout|VbiasP|VbiasP[0] \$400 VDD sg13_lv_pmos L=5u W=1.45u
+ AS=0.493p AD=0.20875p PS=3.58u PD=1.75u
M$611 \$400 VcascodeP$16 Iout VDD sg13_lv_pmos L=0.6u W=1.2u AS=0.20875p
+ AD=0.516p PS=1.75u PD=3.26u
M$612 VDD C11|Iout|VbiasP|VbiasP[0] \$403 VDD sg13_lv_pmos L=5u W=1.45u
+ AS=0.493p AD=0.20875p PS=3.58u PD=1.75u
M$613 \$403 VcascodeP$17 C11|Iout|VbiasP|VbiasP[0] VDD sg13_lv_pmos L=0.6u
+ W=1.2u AS=0.20875p AD=0.516p PS=1.75u PD=3.26u
M$615 C10|C30|VbiasP[2]|VcascP|VcascP[0] C10|C30|VbiasP[2]|VcascP|VcascP[0]
+ C11|C31|Iout|VbiasP|VbiasP[0] VDD sg13_lv_pmos L=0.15u W=11.7u AS=3.978p
+ AD=3.978p PS=24.76u PD=24.76u
M$616 VDD C11|C31|Iout|VbiasP|VbiasP[0] \$408 VDD sg13_lv_pmos L=5u W=1.45u
+ AS=0.493p AD=0.20875p PS=3.58u PD=1.75u
M$617 \$408 VcascodeP$18 C11|C31|Iout|VbiasP|VbiasP[0] VDD sg13_lv_pmos L=0.6u
+ W=1.2u AS=0.20875p AD=0.516p PS=1.75u PD=3.26u
M$618 VDD C11|C31|Iout|VbiasP|VbiasP[0] \$407 VDD sg13_lv_pmos L=5u W=1.45u
+ AS=0.493p AD=0.20875p PS=3.58u PD=1.75u
M$619 \$407 VcascodeP$19 Iout VDD sg13_lv_pmos L=0.6u W=1.2u AS=0.20875p
+ AD=0.516p PS=1.75u PD=3.26u
M$620 VDD C11|C31|Iout|VbiasP|VbiasP[0] \$409 VDD sg13_lv_pmos L=5u W=1.45u
+ AS=0.493p AD=0.20875p PS=3.58u PD=1.75u
M$621 \$409 VcascodeP$20 Iout VDD sg13_lv_pmos L=0.6u W=1.2u AS=0.20875p
+ AD=0.516p PS=1.75u PD=3.26u
M$622 VDD C11|C31|Iout|VbiasP|VbiasP[0] \$410 VDD sg13_lv_pmos L=5u W=1.45u
+ AS=0.493p AD=0.20875p PS=3.58u PD=1.75u
M$623 \$410 VcascodeP$21 Iout VDD sg13_lv_pmos L=0.6u W=1.2u AS=0.20875p
+ AD=0.516p PS=1.75u PD=3.26u
M$624 VDD C11|C31|Iout|VbiasP|VbiasP[0] \$412 VDD sg13_lv_pmos L=5u W=1.45u
+ AS=0.493p AD=0.20875p PS=3.58u PD=1.75u
M$625 \$412 VcascodeP$22 Iout VDD sg13_lv_pmos L=0.6u W=1.2u AS=0.20875p
+ AD=0.516p PS=1.75u PD=3.26u
M$626 VDD C11|C31|Iout|VbiasP|VbiasP[0] \$413 VDD sg13_lv_pmos L=5u W=1.45u
+ AS=0.493p AD=0.20875p PS=3.58u PD=1.75u
M$627 \$413 VcascodeP$23 Iout VDD sg13_lv_pmos L=0.6u W=1.2u AS=0.20875p
+ AD=0.516p PS=1.75u PD=3.26u
M$628 VDD C11|C31|Iout|VbiasP|VbiasP[0] \$415 VDD sg13_lv_pmos L=5u W=1.45u
+ AS=0.493p AD=0.20875p PS=3.58u PD=1.75u
M$629 \$415 VcascodeP$24 Iout VDD sg13_lv_pmos L=0.6u W=1.2u AS=0.20875p
+ AD=0.516p PS=1.75u PD=3.26u
M$630 VDD C11|C31|Iout|VbiasP|VbiasP[0] \$417 VDD sg13_lv_pmos L=5u W=1.45u
+ AS=0.493p AD=0.20875p PS=3.58u PD=1.75u
M$631 \$417 VcascodeP$25 Iout VDD sg13_lv_pmos L=0.6u W=1.2u AS=0.20875p
+ AD=0.516p PS=1.75u PD=3.26u
M$632 VDD C11|C31|Iout|VbiasP|VbiasP[0] \$419 VDD sg13_lv_pmos L=5u W=1.45u
+ AS=0.493p AD=0.20875p PS=3.58u PD=1.75u
M$633 \$419 VcascodeP$26 Iout VDD sg13_lv_pmos L=0.6u W=1.2u AS=0.20875p
+ AD=0.516p PS=1.75u PD=3.26u
M$634 VDD C11|C31|Iout|VbiasP|VbiasP[0] \$421 VDD sg13_lv_pmos L=5u W=1.45u
+ AS=0.493p AD=0.20875p PS=3.58u PD=1.75u
M$635 \$421 VcascodeP$27 Iout VDD sg13_lv_pmos L=0.6u W=1.2u AS=0.20875p
+ AD=0.516p PS=1.75u PD=3.26u
M$636 VDD C11|C31|Iout|VbiasP|VbiasP[0] \$423 VDD sg13_lv_pmos L=5u W=1.45u
+ AS=0.493p AD=0.20875p PS=3.58u PD=1.75u
M$637 \$423 VcascodeP$28 Iout VDD sg13_lv_pmos L=0.6u W=1.2u AS=0.20875p
+ AD=0.516p PS=1.75u PD=3.26u
M$638 VDD C11|C31|Iout|VbiasP|VbiasP[0] \$427 VDD sg13_lv_pmos L=5u W=1.45u
+ AS=0.493p AD=0.20875p PS=3.58u PD=1.75u
M$639 \$427 VcascodeP$29 Iout VDD sg13_lv_pmos L=0.6u W=1.2u AS=0.20875p
+ AD=0.516p PS=1.75u PD=3.26u
M$640 VDD C11|C31|Iout|VbiasP|VbiasP[0] \$424 VDD sg13_lv_pmos L=5u W=1.45u
+ AS=0.493p AD=0.20875p PS=3.58u PD=1.75u
M$641 \$424 VcascodeP$30 Iout VDD sg13_lv_pmos L=0.6u W=1.2u AS=0.20875p
+ AD=0.516p PS=1.75u PD=3.26u
M$642 VDD C11|C31|Iout|VbiasP|VbiasP[0] \$428 VDD sg13_lv_pmos L=5u W=1.45u
+ AS=0.493p AD=0.20875p PS=3.58u PD=1.75u
M$643 \$428 VcascodeP$31 Iout VDD sg13_lv_pmos L=0.6u W=1.2u AS=0.20875p
+ AD=0.516p PS=1.75u PD=3.26u
M$644 VDD C11|C31|Iout|VbiasP|VbiasP[0] \$430 VDD sg13_lv_pmos L=5u W=1.45u
+ AS=0.493p AD=0.20875p PS=3.58u PD=1.75u
M$645 \$430 VcascodeP$32 Iout VDD sg13_lv_pmos L=0.6u W=1.2u AS=0.20875p
+ AD=0.516p PS=1.75u PD=3.26u
M$646 VDD C11|C31|Iout|VbiasP|VbiasP[0] \$433 VDD sg13_lv_pmos L=5u W=1.45u
+ AS=0.493p AD=0.20875p PS=3.58u PD=1.75u
M$647 \$433 VcascodeP$33 Iout VDD sg13_lv_pmos L=0.6u W=1.2u AS=0.20875p
+ AD=0.516p PS=1.75u PD=3.26u
M$648 VDD C11|C31|Iout|VbiasP|VbiasP[0] \$431 VDD sg13_lv_pmos L=5u W=1.45u
+ AS=0.493p AD=0.20875p PS=3.58u PD=1.75u
M$649 \$431 VcascodeP$34 Iout VDD sg13_lv_pmos L=0.6u W=1.2u AS=0.20875p
+ AD=0.516p PS=1.75u PD=3.26u
M$650 VDD C11|C31|Iout|VbiasP|VbiasP[0] \$434 VDD sg13_lv_pmos L=5u W=1.45u
+ AS=0.493p AD=0.20875p PS=3.58u PD=1.75u
M$651 \$434 VcascodeP$35 C11|C31|Iout|VbiasP|VbiasP[0] VDD sg13_lv_pmos L=0.6u
+ W=1.2u AS=0.20875p AD=0.516p PS=1.75u PD=3.26u
M$653 C10|C30|VbiasP[1]|VcascP|VcascP[0] C10|C30|VbiasP[1]|VcascP|VcascP[0]
+ C11|C31|Iout|VbiasP|VbiasP[0]$1 VDD sg13_lv_pmos L=0.15u W=11.7u AS=3.978p
+ AD=3.978p PS=24.76u PD=24.76u
M$654 VDD C11|C31|Iout|VbiasP|VbiasP[0]$1 \$441 VDD sg13_lv_pmos L=5u W=1.45u
+ AS=0.493p AD=0.20875p PS=3.58u PD=1.75u
M$655 \$441 VcascodeP$36 C11|C31|Iout|VbiasP|VbiasP[0]$1 VDD sg13_lv_pmos
+ L=0.6u W=1.2u AS=0.20875p AD=0.516p PS=1.75u PD=3.26u
M$656 VDD C11|C31|Iout|VbiasP|VbiasP[0]$1 \$442 VDD sg13_lv_pmos L=5u W=1.45u
+ AS=0.493p AD=0.20875p PS=3.58u PD=1.75u
M$657 \$442 VcascodeP$37 Iout VDD sg13_lv_pmos L=0.6u W=1.2u AS=0.20875p
+ AD=0.516p PS=1.75u PD=3.26u
M$658 VDD C11|C31|Iout|VbiasP|VbiasP[0]$1 \$439 VDD sg13_lv_pmos L=5u W=1.45u
+ AS=0.493p AD=0.20875p PS=3.58u PD=1.75u
M$659 \$439 VcascodeP$38 Iout VDD sg13_lv_pmos L=0.6u W=1.2u AS=0.20875p
+ AD=0.516p PS=1.75u PD=3.26u
M$660 VDD C11|C31|Iout|VbiasP|VbiasP[0]$1 \$440 VDD sg13_lv_pmos L=5u W=1.45u
+ AS=0.493p AD=0.20875p PS=3.58u PD=1.75u
M$661 \$440 VcascodeP$39 Iout VDD sg13_lv_pmos L=0.6u W=1.2u AS=0.20875p
+ AD=0.516p PS=1.75u PD=3.26u
M$662 VDD C11|C31|Iout|VbiasP|VbiasP[0]$1 \$437 VDD sg13_lv_pmos L=5u W=1.45u
+ AS=0.493p AD=0.20875p PS=3.58u PD=1.75u
M$663 \$437 VcascodeP$40 Iout VDD sg13_lv_pmos L=0.6u W=1.2u AS=0.20875p
+ AD=0.516p PS=1.75u PD=3.26u
M$664 VDD C11|C31|Iout|VbiasP|VbiasP[0]$1 \$438 VDD sg13_lv_pmos L=5u W=1.45u
+ AS=0.493p AD=0.20875p PS=3.58u PD=1.75u
M$665 \$438 VcascodeP$41 Iout VDD sg13_lv_pmos L=0.6u W=1.2u AS=0.20875p
+ AD=0.516p PS=1.75u PD=3.26u
M$666 VDD C11|C31|Iout|VbiasP|VbiasP[0]$1 \$436 VDD sg13_lv_pmos L=5u W=1.45u
+ AS=0.493p AD=0.20875p PS=3.58u PD=1.75u
M$667 \$436 VcascodeP$42 Iout VDD sg13_lv_pmos L=0.6u W=1.2u AS=0.20875p
+ AD=0.516p PS=1.75u PD=3.26u
M$668 VDD C11|C31|Iout|VbiasP|VbiasP[0]$1 \$435 VDD sg13_lv_pmos L=5u W=1.45u
+ AS=0.493p AD=0.20875p PS=3.58u PD=1.75u
M$669 \$435 VcascodeP$43 Iout VDD sg13_lv_pmos L=0.6u W=1.2u AS=0.20875p
+ AD=0.516p PS=1.75u PD=3.26u
M$670 VDD C11|C31|Iout|VbiasP|VbiasP[0]$1 \$432 VDD sg13_lv_pmos L=5u W=1.45u
+ AS=0.493p AD=0.20875p PS=3.58u PD=1.75u
M$671 \$432 VcascodeP$44 Iout VDD sg13_lv_pmos L=0.6u W=1.2u AS=0.20875p
+ AD=0.516p PS=1.75u PD=3.26u
M$672 VDD C11|C31|Iout|VbiasP|VbiasP[0]$1 \$426 VDD sg13_lv_pmos L=5u W=1.45u
+ AS=0.493p AD=0.20875p PS=3.58u PD=1.75u
M$673 \$426 VcascodeP$45 Iout VDD sg13_lv_pmos L=0.6u W=1.2u AS=0.20875p
+ AD=0.516p PS=1.75u PD=3.26u
M$674 VDD C11|C31|Iout|VbiasP|VbiasP[0]$1 \$429 VDD sg13_lv_pmos L=5u W=1.45u
+ AS=0.493p AD=0.20875p PS=3.58u PD=1.75u
M$675 \$429 VcascodeP$46 Iout VDD sg13_lv_pmos L=0.6u W=1.2u AS=0.20875p
+ AD=0.516p PS=1.75u PD=3.26u
M$676 VDD C11|C31|Iout|VbiasP|VbiasP[0]$1 \$425 VDD sg13_lv_pmos L=5u W=1.45u
+ AS=0.493p AD=0.20875p PS=3.58u PD=1.75u
M$677 \$425 VcascodeP$47 Iout VDD sg13_lv_pmos L=0.6u W=1.2u AS=0.20875p
+ AD=0.516p PS=1.75u PD=3.26u
M$678 VDD C11|C31|Iout|VbiasP|VbiasP[0]$1 \$420 VDD sg13_lv_pmos L=5u W=1.45u
+ AS=0.493p AD=0.20875p PS=3.58u PD=1.75u
M$679 \$420 VcascodeP$48 Iout VDD sg13_lv_pmos L=0.6u W=1.2u AS=0.20875p
+ AD=0.516p PS=1.75u PD=3.26u
M$680 VDD C11|C31|Iout|VbiasP|VbiasP[0]$1 \$422 VDD sg13_lv_pmos L=5u W=1.45u
+ AS=0.493p AD=0.20875p PS=3.58u PD=1.75u
M$681 \$422 VcascodeP$49 Iout VDD sg13_lv_pmos L=0.6u W=1.2u AS=0.20875p
+ AD=0.516p PS=1.75u PD=3.26u
M$682 VDD C11|C31|Iout|VbiasP|VbiasP[0]$1 \$418 VDD sg13_lv_pmos L=5u W=1.45u
+ AS=0.493p AD=0.20875p PS=3.58u PD=1.75u
M$683 \$418 VcascodeP$50 Iout VDD sg13_lv_pmos L=0.6u W=1.2u AS=0.20875p
+ AD=0.516p PS=1.75u PD=3.26u
M$684 VDD C11|C31|Iout|VbiasP|VbiasP[0]$1 \$416 VDD sg13_lv_pmos L=5u W=1.45u
+ AS=0.493p AD=0.20875p PS=3.58u PD=1.75u
M$685 \$416 VcascodeP$51 Iout VDD sg13_lv_pmos L=0.6u W=1.2u AS=0.20875p
+ AD=0.516p PS=1.75u PD=3.26u
M$686 VDD C11|C31|Iout|VbiasP|VbiasP[0]$1 \$414 VDD sg13_lv_pmos L=5u W=1.45u
+ AS=0.493p AD=0.20875p PS=3.58u PD=1.75u
M$687 \$414 VcascodeP$52 Iout VDD sg13_lv_pmos L=0.6u W=1.2u AS=0.20875p
+ AD=0.516p PS=1.75u PD=3.26u
M$688 VDD C11|C31|Iout|VbiasP|VbiasP[0]$1 \$411 VDD sg13_lv_pmos L=5u W=1.45u
+ AS=0.493p AD=0.20875p PS=3.58u PD=1.75u
M$689 \$411 VcascodeP$53 C11|C31|Iout|VbiasP|VbiasP[0]$1 VDD sg13_lv_pmos
+ L=0.6u W=1.2u AS=0.20875p AD=0.516p PS=1.75u PD=3.26u
M$691 C10|C30|VbiasP[0]|VcascP|VcascP[0] C10|C30|VbiasP[0]|VcascP|VcascP[0]
+ C11|C31|Iout|VbiasP|VbiasP[0]$2 VDD sg13_lv_pmos L=0.15u W=11.7u AS=3.978p
+ AD=3.978p PS=24.76u PD=24.76u
M$692 VDD C11|C31|Iout|VbiasP|VbiasP[0]$2 \$406 VDD sg13_lv_pmos L=5u W=1.45u
+ AS=0.493p AD=0.20875p PS=3.58u PD=1.75u
M$693 \$406 VcascodeP$54 C11|C31|Iout|VbiasP|VbiasP[0]$2 VDD sg13_lv_pmos
+ L=0.6u W=1.2u AS=0.20875p AD=0.516p PS=1.75u PD=3.26u
M$694 VDD C11|C31|Iout|VbiasP|VbiasP[0]$2 \$405 VDD sg13_lv_pmos L=5u W=1.45u
+ AS=0.493p AD=0.20875p PS=3.58u PD=1.75u
M$695 \$405 VcascodeP$55 Iout VDD sg13_lv_pmos L=0.6u W=1.2u AS=0.20875p
+ AD=0.516p PS=1.75u PD=3.26u
M$696 VDD C11|C31|Iout|VbiasP|VbiasP[0]$2 \$402 VDD sg13_lv_pmos L=5u W=1.45u
+ AS=0.493p AD=0.20875p PS=3.58u PD=1.75u
M$697 \$402 VcascodeP$56 Iout VDD sg13_lv_pmos L=0.6u W=1.2u AS=0.20875p
+ AD=0.516p PS=1.75u PD=3.26u
M$698 VDD C11|C31|Iout|VbiasP|VbiasP[0]$2 \$404 VDD sg13_lv_pmos L=5u W=1.45u
+ AS=0.493p AD=0.20875p PS=3.58u PD=1.75u
M$699 \$404 VcascodeP$57 Iout VDD sg13_lv_pmos L=0.6u W=1.2u AS=0.20875p
+ AD=0.516p PS=1.75u PD=3.26u
M$700 VDD C11|C31|Iout|VbiasP|VbiasP[0]$2 \$398 VDD sg13_lv_pmos L=5u W=1.45u
+ AS=0.493p AD=0.20875p PS=3.58u PD=1.75u
M$701 \$398 VcascodeP$58 Iout VDD sg13_lv_pmos L=0.6u W=1.2u AS=0.20875p
+ AD=0.516p PS=1.75u PD=3.26u
M$702 VDD C11|C31|Iout|VbiasP|VbiasP[0]$2 \$401 VDD sg13_lv_pmos L=5u W=1.45u
+ AS=0.493p AD=0.20875p PS=3.58u PD=1.75u
M$703 \$401 VcascodeP$59 Iout VDD sg13_lv_pmos L=0.6u W=1.2u AS=0.20875p
+ AD=0.516p PS=1.75u PD=3.26u
M$704 VDD C11|C31|Iout|VbiasP|VbiasP[0]$2 \$397 VDD sg13_lv_pmos L=5u W=1.45u
+ AS=0.493p AD=0.20875p PS=3.58u PD=1.75u
M$705 \$397 VcascodeP$60 Iout VDD sg13_lv_pmos L=0.6u W=1.2u AS=0.20875p
+ AD=0.516p PS=1.75u PD=3.26u
M$706 VDD C11|C31|Iout|VbiasP|VbiasP[0]$2 \$395 VDD sg13_lv_pmos L=5u W=1.45u
+ AS=0.493p AD=0.20875p PS=3.58u PD=1.75u
M$707 \$395 VcascodeP$61 Iout VDD sg13_lv_pmos L=0.6u W=1.2u AS=0.20875p
+ AD=0.516p PS=1.75u PD=3.26u
M$708 VDD C11|C31|Iout|VbiasP|VbiasP[0]$2 \$392 VDD sg13_lv_pmos L=5u W=1.45u
+ AS=0.493p AD=0.20875p PS=3.58u PD=1.75u
M$709 \$392 VcascodeP$62 Iout VDD sg13_lv_pmos L=0.6u W=1.2u AS=0.20875p
+ AD=0.516p PS=1.75u PD=3.26u
M$710 VDD C11|C31|Iout|VbiasP|VbiasP[0]$2 \$390 VDD sg13_lv_pmos L=5u W=1.45u
+ AS=0.493p AD=0.20875p PS=3.58u PD=1.75u
M$711 \$390 VcascodeP$63 Iout VDD sg13_lv_pmos L=0.6u W=1.2u AS=0.20875p
+ AD=0.516p PS=1.75u PD=3.26u
M$712 VDD C11|C31|Iout|VbiasP|VbiasP[0]$2 \$388 VDD sg13_lv_pmos L=5u W=1.45u
+ AS=0.493p AD=0.20875p PS=3.58u PD=1.75u
M$713 \$388 VcascodeP$64 Iout VDD sg13_lv_pmos L=0.6u W=1.2u AS=0.20875p
+ AD=0.516p PS=1.75u PD=3.26u
M$714 VDD C11|C31|Iout|VbiasP|VbiasP[0]$2 \$385 VDD sg13_lv_pmos L=5u W=1.45u
+ AS=0.493p AD=0.20875p PS=3.58u PD=1.75u
M$715 \$385 VcascodeP$65 Iout VDD sg13_lv_pmos L=0.6u W=1.2u AS=0.20875p
+ AD=0.516p PS=1.75u PD=3.26u
M$716 VDD C11|C31|Iout|VbiasP|VbiasP[0]$2 \$383 VDD sg13_lv_pmos L=5u W=1.45u
+ AS=0.493p AD=0.20875p PS=3.58u PD=1.75u
M$717 \$383 VcascodeP$66 Iout VDD sg13_lv_pmos L=0.6u W=1.2u AS=0.20875p
+ AD=0.516p PS=1.75u PD=3.26u
M$718 VDD C11|C31|Iout|VbiasP|VbiasP[0]$2 \$381 VDD sg13_lv_pmos L=5u W=1.45u
+ AS=0.493p AD=0.20875p PS=3.58u PD=1.75u
M$719 \$381 VcascodeP$67 Iout VDD sg13_lv_pmos L=0.6u W=1.2u AS=0.20875p
+ AD=0.516p PS=1.75u PD=3.26u
M$720 VDD C11|C31|Iout|VbiasP|VbiasP[0]$2 \$375 VDD sg13_lv_pmos L=5u W=1.45u
+ AS=0.493p AD=0.20875p PS=3.58u PD=1.75u
M$721 \$375 VcascodeP$68 Iout VDD sg13_lv_pmos L=0.6u W=1.2u AS=0.20875p
+ AD=0.516p PS=1.75u PD=3.26u
M$722 VDD C11|C31|Iout|VbiasP|VbiasP[0]$2 \$379 VDD sg13_lv_pmos L=5u W=1.45u
+ AS=0.493p AD=0.20875p PS=3.58u PD=1.75u
M$723 \$379 VcascodeP$69 Iout VDD sg13_lv_pmos L=0.6u W=1.2u AS=0.20875p
+ AD=0.516p PS=1.75u PD=3.26u
M$724 VDD C11|C31|Iout|VbiasP|VbiasP[0]$2 \$373 VDD sg13_lv_pmos L=5u W=1.45u
+ AS=0.493p AD=0.20875p PS=3.58u PD=1.75u
M$725 \$373 VcascodeP$70 Iout VDD sg13_lv_pmos L=0.6u W=1.2u AS=0.20875p
+ AD=0.516p PS=1.75u PD=3.26u
M$726 VDD C11|C31|Iout|VbiasP|VbiasP[0]$2 \$371 VDD sg13_lv_pmos L=5u W=1.45u
+ AS=0.493p AD=0.20875p PS=3.58u PD=1.75u
M$727 \$371 VcascodeP$71 C11|C31|Iout|VbiasP|VbiasP[0]$2 VDD sg13_lv_pmos
+ L=0.6u W=1.2u AS=0.20875p AD=0.516p PS=1.75u PD=3.26u
M$729 C00|VbiasP[4]|VcascP|VcascP[1] C00|VbiasP[4]|VcascP|VcascP[1]
+ C01|Iout|VbiasP|VbiasP[1] VDD sg13_lv_pmos L=0.15u W=11.7u AS=3.978p
+ AD=3.978p PS=24.76u PD=24.76u
M$730 Iout VcascodeP$73 \$525 VDD sg13_lv_pmos L=0.6u W=1.2u AS=0.516p
+ AD=0.20875p PS=3.26u PD=1.75u
M$731 \$525 C01|Iout|VbiasP|VbiasP[1] VDD VDD sg13_lv_pmos L=5u W=1.45u
+ AS=0.20875p AD=0.493p PS=1.75u PD=3.58u
M$732 Iout VcascodeP$74 \$526 VDD sg13_lv_pmos L=0.6u W=1.2u AS=0.516p
+ AD=0.20875p PS=3.26u PD=1.75u
M$733 \$526 C01|Iout|VbiasP|VbiasP[1] VDD VDD sg13_lv_pmos L=5u W=1.45u
+ AS=0.20875p AD=0.493p PS=1.75u PD=3.58u
M$734 Iout VcascodeP$75 \$527 VDD sg13_lv_pmos L=0.6u W=1.2u AS=0.516p
+ AD=0.20875p PS=3.26u PD=1.75u
M$735 \$527 C01|Iout|VbiasP|VbiasP[1] VDD VDD sg13_lv_pmos L=5u W=1.45u
+ AS=0.20875p AD=0.493p PS=1.75u PD=3.58u
M$736 Iout VcascodeP$76 \$528 VDD sg13_lv_pmos L=0.6u W=1.2u AS=0.516p
+ AD=0.20875p PS=3.26u PD=1.75u
M$737 \$528 C01|Iout|VbiasP|VbiasP[1] VDD VDD sg13_lv_pmos L=5u W=1.45u
+ AS=0.20875p AD=0.493p PS=1.75u PD=3.58u
M$738 Iout VcascodeP$77 \$530 VDD sg13_lv_pmos L=0.6u W=1.2u AS=0.516p
+ AD=0.20875p PS=3.26u PD=1.75u
M$739 \$530 C01|Iout|VbiasP|VbiasP[1] VDD VDD sg13_lv_pmos L=5u W=1.45u
+ AS=0.20875p AD=0.493p PS=1.75u PD=3.58u
M$740 Iout VcascodeP$78 \$529 VDD sg13_lv_pmos L=0.6u W=1.2u AS=0.516p
+ AD=0.20875p PS=3.26u PD=1.75u
M$741 \$529 C01|Iout|VbiasP|VbiasP[1] VDD VDD sg13_lv_pmos L=5u W=1.45u
+ AS=0.20875p AD=0.493p PS=1.75u PD=3.58u
M$742 Iout VcascodeP$79 \$531 VDD sg13_lv_pmos L=0.6u W=1.2u AS=0.516p
+ AD=0.20875p PS=3.26u PD=1.75u
M$743 \$531 C01|Iout|VbiasP|VbiasP[1] VDD VDD sg13_lv_pmos L=5u W=1.45u
+ AS=0.20875p AD=0.493p PS=1.75u PD=3.58u
M$744 Iout VcascodeP$81 \$533 VDD sg13_lv_pmos L=0.6u W=1.2u AS=0.516p
+ AD=0.20875p PS=3.26u PD=1.75u
M$745 \$533 C01|Iout|VbiasP|VbiasP[1] VDD VDD sg13_lv_pmos L=5u W=1.45u
+ AS=0.20875p AD=0.493p PS=1.75u PD=3.58u
M$746 Iout VcascodeP$82 \$534 VDD sg13_lv_pmos L=0.6u W=1.2u AS=0.516p
+ AD=0.20875p PS=3.26u PD=1.75u
M$747 \$534 C01|Iout|VbiasP|VbiasP[1] VDD VDD sg13_lv_pmos L=5u W=1.45u
+ AS=0.20875p AD=0.493p PS=1.75u PD=3.58u
M$748 Iout VcascodeP$83 \$535 VDD sg13_lv_pmos L=0.6u W=1.2u AS=0.516p
+ AD=0.20875p PS=3.26u PD=1.75u
M$749 \$535 C01|Iout|VbiasP|VbiasP[1] VDD VDD sg13_lv_pmos L=5u W=1.45u
+ AS=0.20875p AD=0.493p PS=1.75u PD=3.58u
M$750 Iout VcascodeP$84 \$536 VDD sg13_lv_pmos L=0.6u W=1.2u AS=0.516p
+ AD=0.20875p PS=3.26u PD=1.75u
M$751 \$536 C01|Iout|VbiasP|VbiasP[1] VDD VDD sg13_lv_pmos L=5u W=1.45u
+ AS=0.20875p AD=0.493p PS=1.75u PD=3.58u
M$752 Iout VcascodeP$86 \$538 VDD sg13_lv_pmos L=0.6u W=1.2u AS=0.516p
+ AD=0.20875p PS=3.26u PD=1.75u
M$753 \$538 C01|Iout|VbiasP|VbiasP[1] VDD VDD sg13_lv_pmos L=5u W=1.45u
+ AS=0.20875p AD=0.493p PS=1.75u PD=3.58u
M$754 Iout VcascodeP$87 \$539 VDD sg13_lv_pmos L=0.6u W=1.2u AS=0.516p
+ AD=0.20875p PS=3.26u PD=1.75u
M$755 \$539 C01|Iout|VbiasP|VbiasP[1] VDD VDD sg13_lv_pmos L=5u W=1.45u
+ AS=0.20875p AD=0.493p PS=1.75u PD=3.58u
M$756 Iout VcascodeP$88 \$540 VDD sg13_lv_pmos L=0.6u W=1.2u AS=0.516p
+ AD=0.20875p PS=3.26u PD=1.75u
M$757 \$540 C01|Iout|VbiasP|VbiasP[1] VDD VDD sg13_lv_pmos L=5u W=1.45u
+ AS=0.20875p AD=0.493p PS=1.75u PD=3.58u
M$758 C01|Iout|VbiasP|VbiasP[1] VcascodeP$89 \$541 VDD sg13_lv_pmos L=0.6u
+ W=1.2u AS=0.516p AD=0.20875p PS=3.26u PD=1.75u
M$759 \$541 C01|Iout|VbiasP|VbiasP[1] VDD VDD sg13_lv_pmos L=5u W=1.45u
+ AS=0.20875p AD=0.493p PS=1.75u PD=3.58u
M$761 C00|C20|VbiasP[5]|VcascP|VcascP[1] C00|C20|VbiasP[5]|VcascP|VcascP[1]
+ C01|C21|Iout|VbiasP|VbiasP[1] VDD sg13_lv_pmos L=0.15u W=11.7u AS=3.978p
+ AD=3.978p PS=24.76u PD=24.76u
M$762 C01|C21|Iout|VbiasP|VbiasP[1] VcascodeP$90 \$545 VDD sg13_lv_pmos L=0.6u
+ W=1.2u AS=0.516p AD=0.20875p PS=3.26u PD=1.75u
M$763 \$545 C01|C21|Iout|VbiasP|VbiasP[1] VDD VDD sg13_lv_pmos L=5u W=1.45u
+ AS=0.20875p AD=0.493p PS=1.75u PD=3.58u
M$764 Iout VcascodeP$92 \$548 VDD sg13_lv_pmos L=0.6u W=1.2u AS=0.516p
+ AD=0.20875p PS=3.26u PD=1.75u
M$765 \$548 C01|C21|Iout|VbiasP|VbiasP[1] VDD VDD sg13_lv_pmos L=5u W=1.45u
+ AS=0.20875p AD=0.493p PS=1.75u PD=3.58u
M$766 Iout VcascodeP$93 \$547 VDD sg13_lv_pmos L=0.6u W=1.2u AS=0.516p
+ AD=0.20875p PS=3.26u PD=1.75u
M$767 \$547 C01|C21|Iout|VbiasP|VbiasP[1] VDD VDD sg13_lv_pmos L=5u W=1.45u
+ AS=0.20875p AD=0.493p PS=1.75u PD=3.58u
M$768 Iout VcascodeP$94 \$549 VDD sg13_lv_pmos L=0.6u W=1.2u AS=0.516p
+ AD=0.20875p PS=3.26u PD=1.75u
M$769 \$549 C01|C21|Iout|VbiasP|VbiasP[1] VDD VDD sg13_lv_pmos L=5u W=1.45u
+ AS=0.20875p AD=0.493p PS=1.75u PD=3.58u
M$770 Iout VcascodeP$96 \$553 VDD sg13_lv_pmos L=0.6u W=1.2u AS=0.516p
+ AD=0.20875p PS=3.26u PD=1.75u
M$771 \$553 C01|C21|Iout|VbiasP|VbiasP[1] VDD VDD sg13_lv_pmos L=5u W=1.45u
+ AS=0.20875p AD=0.493p PS=1.75u PD=3.58u
M$772 Iout VcascodeP$98 \$554 VDD sg13_lv_pmos L=0.6u W=1.2u AS=0.516p
+ AD=0.20875p PS=3.26u PD=1.75u
M$773 \$554 C01|C21|Iout|VbiasP|VbiasP[1] VDD VDD sg13_lv_pmos L=5u W=1.45u
+ AS=0.20875p AD=0.493p PS=1.75u PD=3.58u
M$774 Iout VcascodeP$99 \$556 VDD sg13_lv_pmos L=0.6u W=1.2u AS=0.516p
+ AD=0.20875p PS=3.26u PD=1.75u
M$775 \$556 C01|C21|Iout|VbiasP|VbiasP[1] VDD VDD sg13_lv_pmos L=5u W=1.45u
+ AS=0.20875p AD=0.493p PS=1.75u PD=3.58u
M$776 Iout VcascodeP$100 \$557 VDD sg13_lv_pmos L=0.6u W=1.2u AS=0.516p
+ AD=0.20875p PS=3.26u PD=1.75u
M$777 \$557 C01|C21|Iout|VbiasP|VbiasP[1] VDD VDD sg13_lv_pmos L=5u W=1.45u
+ AS=0.20875p AD=0.493p PS=1.75u PD=3.58u
M$778 Iout VcascodeP$101 \$558 VDD sg13_lv_pmos L=0.6u W=1.2u AS=0.516p
+ AD=0.20875p PS=3.26u PD=1.75u
M$779 \$558 C01|C21|Iout|VbiasP|VbiasP[1] VDD VDD sg13_lv_pmos L=5u W=1.45u
+ AS=0.20875p AD=0.493p PS=1.75u PD=3.58u
M$780 Iout VcascodeP$102 \$559 VDD sg13_lv_pmos L=0.6u W=1.2u AS=0.516p
+ AD=0.20875p PS=3.26u PD=1.75u
M$781 \$559 C01|C21|Iout|VbiasP|VbiasP[1] VDD VDD sg13_lv_pmos L=5u W=1.45u
+ AS=0.20875p AD=0.493p PS=1.75u PD=3.58u
M$782 Iout VcascodeP$104 \$560 VDD sg13_lv_pmos L=0.6u W=1.2u AS=0.516p
+ AD=0.20875p PS=3.26u PD=1.75u
M$783 \$560 C01|C21|Iout|VbiasP|VbiasP[1] VDD VDD sg13_lv_pmos L=5u W=1.45u
+ AS=0.20875p AD=0.493p PS=1.75u PD=3.58u
M$784 Iout VcascodeP$105 \$562 VDD sg13_lv_pmos L=0.6u W=1.2u AS=0.516p
+ AD=0.20875p PS=3.26u PD=1.75u
M$785 \$562 C01|C21|Iout|VbiasP|VbiasP[1] VDD VDD sg13_lv_pmos L=5u W=1.45u
+ AS=0.20875p AD=0.493p PS=1.75u PD=3.58u
M$786 Iout VcascodeP$106 \$564 VDD sg13_lv_pmos L=0.6u W=1.2u AS=0.516p
+ AD=0.20875p PS=3.26u PD=1.75u
M$787 \$564 C01|C21|Iout|VbiasP|VbiasP[1] VDD VDD sg13_lv_pmos L=5u W=1.45u
+ AS=0.20875p AD=0.493p PS=1.75u PD=3.58u
M$788 C01|C21|Iout|VbiasP|VbiasP[1] VcascodeP$107 \$563 VDD sg13_lv_pmos L=0.6u
+ W=1.2u AS=0.516p AD=0.20875p PS=3.26u PD=1.75u
M$789 \$563 C01|C21|Iout|VbiasP|VbiasP[1] VDD VDD sg13_lv_pmos L=5u W=1.45u
+ AS=0.20875p AD=0.493p PS=1.75u PD=3.58u
M$791 C00|C20|VbiasP[6]|VcascP|VcascP[1] C00|C20|VbiasP[6]|VcascP|VcascP[1]
+ C01|C21|Iout|VbiasP|VbiasP[1]$1 VDD sg13_lv_pmos L=0.15u W=11.7u AS=3.978p
+ AD=3.978p PS=24.76u PD=24.76u
M$792 Iout VcascodeP$109 \$570 VDD sg13_lv_pmos L=0.6u W=1.2u AS=0.516p
+ AD=0.20875p PS=3.26u PD=1.75u
M$793 \$570 C01|C21|Iout|VbiasP|VbiasP[1]$1 VDD VDD sg13_lv_pmos L=5u W=1.45u
+ AS=0.20875p AD=0.493p PS=1.75u PD=3.58u
M$794 Iout VcascodeP$110 \$571 VDD sg13_lv_pmos L=0.6u W=1.2u AS=0.516p
+ AD=0.20875p PS=3.26u PD=1.75u
M$795 \$571 C01|C21|Iout|VbiasP|VbiasP[1]$1 VDD VDD sg13_lv_pmos L=5u W=1.45u
+ AS=0.20875p AD=0.493p PS=1.75u PD=3.58u
M$796 Iout VcascodeP$112 \$576 VDD sg13_lv_pmos L=0.6u W=1.2u AS=0.516p
+ AD=0.20875p PS=3.26u PD=1.75u
M$797 \$576 C01|C21|Iout|VbiasP|VbiasP[1]$1 VDD VDD sg13_lv_pmos L=5u W=1.45u
+ AS=0.20875p AD=0.493p PS=1.75u PD=3.58u
M$798 Iout VcascodeP$113 \$575 VDD sg13_lv_pmos L=0.6u W=1.2u AS=0.516p
+ AD=0.20875p PS=3.26u PD=1.75u
M$799 \$575 C01|C21|Iout|VbiasP|VbiasP[1]$1 VDD VDD sg13_lv_pmos L=5u W=1.45u
+ AS=0.20875p AD=0.493p PS=1.75u PD=3.58u
M$800 Iout VcascodeP$114 \$577 VDD sg13_lv_pmos L=0.6u W=1.2u AS=0.516p
+ AD=0.20875p PS=3.26u PD=1.75u
M$801 \$577 C01|C21|Iout|VbiasP|VbiasP[1]$1 VDD VDD sg13_lv_pmos L=5u W=1.45u
+ AS=0.20875p AD=0.493p PS=1.75u PD=3.58u
M$802 Iout VcascodeP$115 \$579 VDD sg13_lv_pmos L=0.6u W=1.2u AS=0.516p
+ AD=0.20875p PS=3.26u PD=1.75u
M$803 \$579 C01|C21|Iout|VbiasP|VbiasP[1]$1 VDD VDD sg13_lv_pmos L=5u W=1.45u
+ AS=0.20875p AD=0.493p PS=1.75u PD=3.58u
M$804 Iout VcascodeP$116 \$578 VDD sg13_lv_pmos L=0.6u W=1.2u AS=0.516p
+ AD=0.20875p PS=3.26u PD=1.75u
M$805 \$578 C01|C21|Iout|VbiasP|VbiasP[1]$1 VDD VDD sg13_lv_pmos L=5u W=1.45u
+ AS=0.20875p AD=0.493p PS=1.75u PD=3.58u
M$806 Iout VcascodeP$118 \$580 VDD sg13_lv_pmos L=0.6u W=1.2u AS=0.516p
+ AD=0.20875p PS=3.26u PD=1.75u
M$807 \$580 C01|C21|Iout|VbiasP|VbiasP[1]$1 VDD VDD sg13_lv_pmos L=5u W=1.45u
+ AS=0.20875p AD=0.493p PS=1.75u PD=3.58u
M$808 Iout VcascodeP$121 \$583 VDD sg13_lv_pmos L=0.6u W=1.2u AS=0.516p
+ AD=0.20875p PS=3.26u PD=1.75u
M$809 \$583 C01|C21|Iout|VbiasP|VbiasP[1]$1 VDD VDD sg13_lv_pmos L=5u W=1.45u
+ AS=0.20875p AD=0.493p PS=1.75u PD=3.58u
M$810 Iout VcascodeP$122 \$586 VDD sg13_lv_pmos L=0.6u W=1.2u AS=0.516p
+ AD=0.20875p PS=3.26u PD=1.75u
M$811 \$586 C01|C21|Iout|VbiasP|VbiasP[1]$1 VDD VDD sg13_lv_pmos L=5u W=1.45u
+ AS=0.20875p AD=0.493p PS=1.75u PD=3.58u
M$812 Iout VcascodeP$123 \$588 VDD sg13_lv_pmos L=0.6u W=1.2u AS=0.516p
+ AD=0.20875p PS=3.26u PD=1.75u
M$813 \$588 C01|C21|Iout|VbiasP|VbiasP[1]$1 VDD VDD sg13_lv_pmos L=5u W=1.45u
+ AS=0.20875p AD=0.493p PS=1.75u PD=3.58u
M$814 Iout VcascodeP$124 \$587 VDD sg13_lv_pmos L=0.6u W=1.2u AS=0.516p
+ AD=0.20875p PS=3.26u PD=1.75u
M$815 \$587 C01|C21|Iout|VbiasP|VbiasP[1]$1 VDD VDD sg13_lv_pmos L=5u W=1.45u
+ AS=0.20875p AD=0.493p PS=1.75u PD=3.58u
M$816 C01|C21|Iout|VbiasP|VbiasP[1]$1 VcascodeP$125 \$589 VDD sg13_lv_pmos
+ L=0.6u W=1.2u AS=0.516p AD=0.20875p PS=3.26u PD=1.75u
M$817 \$589 C01|C21|Iout|VbiasP|VbiasP[1]$1 VDD VDD sg13_lv_pmos L=5u W=1.45u
+ AS=0.20875p AD=0.493p PS=1.75u PD=3.58u
M$819 C00|C20|VbiasP[7]|VcascP|VcascP[1] C00|C20|VbiasP[7]|VcascP|VcascP[1]
+ C01|C21|Iout|VbiasP|VbiasP[1]$2 VDD sg13_lv_pmos L=0.15u W=11.7u AS=3.978p
+ AD=3.978p PS=24.76u PD=24.76u
M$820 C01|C21|Iout|VbiasP|VbiasP[1]$2 VcascodeP$126 \$595 VDD sg13_lv_pmos
+ L=0.6u W=1.2u AS=0.516p AD=0.20875p PS=3.26u PD=1.75u
M$821 \$595 C01|C21|Iout|VbiasP|VbiasP[1]$2 VDD VDD sg13_lv_pmos L=5u W=1.45u
+ AS=0.20875p AD=0.493p PS=1.75u PD=3.58u
M$822 Iout VcascodeP$127 \$594 VDD sg13_lv_pmos L=0.6u W=1.2u AS=0.516p
+ AD=0.20875p PS=3.26u PD=1.75u
M$823 \$594 C01|C21|Iout|VbiasP|VbiasP[1]$2 VDD VDD sg13_lv_pmos L=5u W=1.45u
+ AS=0.20875p AD=0.493p PS=1.75u PD=3.58u
M$824 Iout VcascodeP$129 \$593 VDD sg13_lv_pmos L=0.6u W=1.2u AS=0.516p
+ AD=0.20875p PS=3.26u PD=1.75u
M$825 \$593 C01|C21|Iout|VbiasP|VbiasP[1]$2 VDD VDD sg13_lv_pmos L=5u W=1.45u
+ AS=0.20875p AD=0.493p PS=1.75u PD=3.58u
M$826 Iout VcascodeP$130 \$591 VDD sg13_lv_pmos L=0.6u W=1.2u AS=0.516p
+ AD=0.20875p PS=3.26u PD=1.75u
M$827 \$591 C01|C21|Iout|VbiasP|VbiasP[1]$2 VDD VDD sg13_lv_pmos L=5u W=1.45u
+ AS=0.20875p AD=0.493p PS=1.75u PD=3.58u
M$828 Iout VcascodeP$131 \$585 VDD sg13_lv_pmos L=0.6u W=1.2u AS=0.516p
+ AD=0.20875p PS=3.26u PD=1.75u
M$829 \$585 C01|C21|Iout|VbiasP|VbiasP[1]$2 VDD VDD sg13_lv_pmos L=5u W=1.45u
+ AS=0.20875p AD=0.493p PS=1.75u PD=3.58u
M$830 Iout VcascodeP$133 \$573 VDD sg13_lv_pmos L=0.6u W=1.2u AS=0.516p
+ AD=0.20875p PS=3.26u PD=1.75u
M$831 \$573 C01|C21|Iout|VbiasP|VbiasP[1]$2 VDD VDD sg13_lv_pmos L=5u W=1.45u
+ AS=0.20875p AD=0.493p PS=1.75u PD=3.58u
M$832 Iout VcascodeP$135 \$572 VDD sg13_lv_pmos L=0.6u W=1.2u AS=0.516p
+ AD=0.20875p PS=3.26u PD=1.75u
M$833 \$572 C01|C21|Iout|VbiasP|VbiasP[1]$2 VDD VDD sg13_lv_pmos L=5u W=1.45u
+ AS=0.20875p AD=0.493p PS=1.75u PD=3.58u
M$834 Iout VcascodeP$137 \$566 VDD sg13_lv_pmos L=0.6u W=1.2u AS=0.516p
+ AD=0.20875p PS=3.26u PD=1.75u
M$835 \$566 C01|C21|Iout|VbiasP|VbiasP[1]$2 VDD VDD sg13_lv_pmos L=5u W=1.45u
+ AS=0.20875p AD=0.493p PS=1.75u PD=3.58u
M$836 Iout VcascodeP$138 \$565 VDD sg13_lv_pmos L=0.6u W=1.2u AS=0.516p
+ AD=0.20875p PS=3.26u PD=1.75u
M$837 \$565 C01|C21|Iout|VbiasP|VbiasP[1]$2 VDD VDD sg13_lv_pmos L=5u W=1.45u
+ AS=0.20875p AD=0.493p PS=1.75u PD=3.58u
M$838 Iout VcascodeP$139 \$550 VDD sg13_lv_pmos L=0.6u W=1.2u AS=0.516p
+ AD=0.20875p PS=3.26u PD=1.75u
M$839 \$550 C01|C21|Iout|VbiasP|VbiasP[1]$2 VDD VDD sg13_lv_pmos L=5u W=1.45u
+ AS=0.20875p AD=0.493p PS=1.75u PD=3.58u
M$840 Iout VcascodeP$141 \$544 VDD sg13_lv_pmos L=0.6u W=1.2u AS=0.516p
+ AD=0.20875p PS=3.26u PD=1.75u
M$841 \$544 C01|C21|Iout|VbiasP|VbiasP[1]$2 VDD VDD sg13_lv_pmos L=5u W=1.45u
+ AS=0.20875p AD=0.493p PS=1.75u PD=3.58u
M$842 Iout VcascodeP$142 \$542 VDD sg13_lv_pmos L=0.6u W=1.2u AS=0.516p
+ AD=0.20875p PS=3.26u PD=1.75u
M$843 \$542 C01|C21|Iout|VbiasP|VbiasP[1]$2 VDD VDD sg13_lv_pmos L=5u W=1.45u
+ AS=0.20875p AD=0.493p PS=1.75u PD=3.58u
M$844 C01|C21|Iout|VbiasP|VbiasP[1]$2 VcascodeP$143 \$543 VDD sg13_lv_pmos
+ L=0.6u W=1.2u AS=0.516p AD=0.20875p PS=3.26u PD=1.75u
M$845 \$543 C01|C21|Iout|VbiasP|VbiasP[1]$2 VDD VDD sg13_lv_pmos L=5u W=1.45u
+ AS=0.20875p AD=0.493p PS=1.75u PD=3.58u
M$847 C01|Iout|VbiasP|VbiasP[1] VcascodeP$72 \$524 VDD sg13_lv_pmos L=0.6u
+ W=1.2u AS=0.516p AD=0.20875p PS=3.26u PD=1.75u
M$848 \$524 C01|Iout|VbiasP|VbiasP[1] VDD VDD sg13_lv_pmos L=5u W=1.45u
+ AS=0.20875p AD=0.493p PS=1.75u PD=3.58u
M$849 Iout VcascodeP$80 \$532 VDD sg13_lv_pmos L=0.6u W=1.2u AS=0.516p
+ AD=0.20875p PS=3.26u PD=1.75u
M$850 \$532 C01|Iout|VbiasP|VbiasP[1] VDD VDD sg13_lv_pmos L=5u W=1.45u
+ AS=0.20875p AD=0.493p PS=1.75u PD=3.58u
M$851 Iout VcascodeP$85 \$537 VDD sg13_lv_pmos L=0.6u W=1.2u AS=0.516p
+ AD=0.20875p PS=3.26u PD=1.75u
M$852 \$537 C01|Iout|VbiasP|VbiasP[1] VDD VDD sg13_lv_pmos L=5u W=1.45u
+ AS=0.20875p AD=0.493p PS=1.75u PD=3.58u
M$853 Iout VcascodeP$91 \$546 VDD sg13_lv_pmos L=0.6u W=1.2u AS=0.516p
+ AD=0.20875p PS=3.26u PD=1.75u
M$854 \$546 C01|C21|Iout|VbiasP|VbiasP[1] VDD VDD sg13_lv_pmos L=5u W=1.45u
+ AS=0.20875p AD=0.493p PS=1.75u PD=3.58u
M$855 Iout VcascodeP$95 \$551 VDD sg13_lv_pmos L=0.6u W=1.2u AS=0.516p
+ AD=0.20875p PS=3.26u PD=1.75u
M$856 \$551 C01|C21|Iout|VbiasP|VbiasP[1] VDD VDD sg13_lv_pmos L=5u W=1.45u
+ AS=0.20875p AD=0.493p PS=1.75u PD=3.58u
M$857 Iout VcascodeP$97 \$552 VDD sg13_lv_pmos L=0.6u W=1.2u AS=0.516p
+ AD=0.20875p PS=3.26u PD=1.75u
M$858 \$552 C01|C21|Iout|VbiasP|VbiasP[1] VDD VDD sg13_lv_pmos L=5u W=1.45u
+ AS=0.20875p AD=0.493p PS=1.75u PD=3.58u
M$859 Iout VcascodeP$103 \$561 VDD sg13_lv_pmos L=0.6u W=1.2u AS=0.516p
+ AD=0.20875p PS=3.26u PD=1.75u
M$860 \$561 C01|C21|Iout|VbiasP|VbiasP[1] VDD VDD sg13_lv_pmos L=5u W=1.45u
+ AS=0.20875p AD=0.493p PS=1.75u PD=3.58u
M$861 C01|C21|Iout|VbiasP|VbiasP[1]$1 VcascodeP$108 \$569 VDD sg13_lv_pmos
+ L=0.6u W=1.2u AS=0.516p AD=0.20875p PS=3.26u PD=1.75u
M$862 \$569 C01|C21|Iout|VbiasP|VbiasP[1]$1 VDD VDD sg13_lv_pmos L=5u W=1.45u
+ AS=0.20875p AD=0.493p PS=1.75u PD=3.58u
M$863 Iout VcascodeP$111 \$574 VDD sg13_lv_pmos L=0.6u W=1.2u AS=0.516p
+ AD=0.20875p PS=3.26u PD=1.75u
M$864 \$574 C01|C21|Iout|VbiasP|VbiasP[1]$1 VDD VDD sg13_lv_pmos L=5u W=1.45u
+ AS=0.20875p AD=0.493p PS=1.75u PD=3.58u
M$865 Iout VcascodeP$117 \$581 VDD sg13_lv_pmos L=0.6u W=1.2u AS=0.516p
+ AD=0.20875p PS=3.26u PD=1.75u
M$866 \$581 C01|C21|Iout|VbiasP|VbiasP[1]$1 VDD VDD sg13_lv_pmos L=5u W=1.45u
+ AS=0.20875p AD=0.493p PS=1.75u PD=3.58u
M$867 Iout VcascodeP$119 \$582 VDD sg13_lv_pmos L=0.6u W=1.2u AS=0.516p
+ AD=0.20875p PS=3.26u PD=1.75u
M$868 \$582 C01|C21|Iout|VbiasP|VbiasP[1]$1 VDD VDD sg13_lv_pmos L=5u W=1.45u
+ AS=0.20875p AD=0.493p PS=1.75u PD=3.58u
M$869 Iout VcascodeP$120 \$584 VDD sg13_lv_pmos L=0.6u W=1.2u AS=0.516p
+ AD=0.20875p PS=3.26u PD=1.75u
M$870 \$584 C01|C21|Iout|VbiasP|VbiasP[1]$1 VDD VDD sg13_lv_pmos L=5u W=1.45u
+ AS=0.20875p AD=0.493p PS=1.75u PD=3.58u
M$871 Iout VcascodeP$128 \$592 VDD sg13_lv_pmos L=0.6u W=1.2u AS=0.516p
+ AD=0.20875p PS=3.26u PD=1.75u
M$872 \$592 C01|C21|Iout|VbiasP|VbiasP[1]$2 VDD VDD sg13_lv_pmos L=5u W=1.45u
+ AS=0.20875p AD=0.493p PS=1.75u PD=3.58u
M$873 Iout VcascodeP$132 \$590 VDD sg13_lv_pmos L=0.6u W=1.2u AS=0.516p
+ AD=0.20875p PS=3.26u PD=1.75u
M$874 \$590 C01|C21|Iout|VbiasP|VbiasP[1]$2 VDD VDD sg13_lv_pmos L=5u W=1.45u
+ AS=0.20875p AD=0.493p PS=1.75u PD=3.58u
M$875 Iout VcascodeP$134 \$568 VDD sg13_lv_pmos L=0.6u W=1.2u AS=0.516p
+ AD=0.20875p PS=3.26u PD=1.75u
M$876 \$568 C01|C21|Iout|VbiasP|VbiasP[1]$2 VDD VDD sg13_lv_pmos L=5u W=1.45u
+ AS=0.20875p AD=0.493p PS=1.75u PD=3.58u
M$877 Iout VcascodeP$136 \$567 VDD sg13_lv_pmos L=0.6u W=1.2u AS=0.516p
+ AD=0.20875p PS=3.26u PD=1.75u
M$878 \$567 C01|C21|Iout|VbiasP|VbiasP[1]$2 VDD VDD sg13_lv_pmos L=5u W=1.45u
+ AS=0.20875p AD=0.493p PS=1.75u PD=3.58u
M$879 Iout VcascodeP$140 \$555 VDD sg13_lv_pmos L=0.6u W=1.2u AS=0.516p
+ AD=0.20875p PS=3.26u PD=1.75u
M$880 \$555 C01|C21|Iout|VbiasP|VbiasP[1]$2 VDD VDD sg13_lv_pmos L=5u W=1.45u
+ AS=0.20875p AD=0.493p PS=1.75u PD=3.58u
M$881 VDD OUTP$72 VcascodeP$72 VDD sg13_lv_pmos L=0.13u W=0.3u AS=0.102p
+ AD=0.057p PS=1.28u PD=0.68u
M$882 VcascodeP$72 OUTN$72 C00|VbiasP[4]|VcascP|VcascP[1] VDD sg13_lv_pmos
+ L=0.13u W=0.3u AS=0.057p AD=0.102p PS=0.68u PD=1.28u
M$883 VDD OUTP$73 VcascodeP$73 VDD sg13_lv_pmos L=0.13u W=0.3u AS=0.102p
+ AD=0.057p PS=1.28u PD=0.68u
M$884 VcascodeP$73 OUTN$73 C00|VbiasP[4]|VcascP|VcascP[1] VDD sg13_lv_pmos
+ L=0.13u W=0.3u AS=0.057p AD=0.102p PS=0.68u PD=1.28u
M$885 VDD OUTP$74 VcascodeP$74 VDD sg13_lv_pmos L=0.13u W=0.3u AS=0.102p
+ AD=0.057p PS=1.28u PD=0.68u
M$886 VcascodeP$74 OUTN$74 C00|VbiasP[4]|VcascP|VcascP[1] VDD sg13_lv_pmos
+ L=0.13u W=0.3u AS=0.057p AD=0.102p PS=0.68u PD=1.28u
M$887 VDD OUTP$75 VcascodeP$75 VDD sg13_lv_pmos L=0.13u W=0.3u AS=0.102p
+ AD=0.057p PS=1.28u PD=0.68u
M$888 VcascodeP$75 OUTN$75 C00|VbiasP[4]|VcascP|VcascP[1] VDD sg13_lv_pmos
+ L=0.13u W=0.3u AS=0.057p AD=0.102p PS=0.68u PD=1.28u
M$889 VDD OUTP$76 VcascodeP$76 VDD sg13_lv_pmos L=0.13u W=0.3u AS=0.102p
+ AD=0.057p PS=1.28u PD=0.68u
M$890 VcascodeP$76 OUTN$76 C00|VbiasP[4]|VcascP|VcascP[1] VDD sg13_lv_pmos
+ L=0.13u W=0.3u AS=0.057p AD=0.102p PS=0.68u PD=1.28u
M$891 VDD OUTP$77 VcascodeP$77 VDD sg13_lv_pmos L=0.13u W=0.3u AS=0.102p
+ AD=0.057p PS=1.28u PD=0.68u
M$892 VcascodeP$77 OUTN$77 C00|VbiasP[4]|VcascP|VcascP[1] VDD sg13_lv_pmos
+ L=0.13u W=0.3u AS=0.057p AD=0.102p PS=0.68u PD=1.28u
M$893 VDD OUTP$78 VcascodeP$78 VDD sg13_lv_pmos L=0.13u W=0.3u AS=0.102p
+ AD=0.057p PS=1.28u PD=0.68u
M$894 VcascodeP$78 OUTN$78 C00|VbiasP[4]|VcascP|VcascP[1] VDD sg13_lv_pmos
+ L=0.13u W=0.3u AS=0.057p AD=0.102p PS=0.68u PD=1.28u
M$895 VDD OUTP$79 VcascodeP$79 VDD sg13_lv_pmos L=0.13u W=0.3u AS=0.102p
+ AD=0.057p PS=1.28u PD=0.68u
M$896 VcascodeP$79 OUTN$79 C00|VbiasP[4]|VcascP|VcascP[1] VDD sg13_lv_pmos
+ L=0.13u W=0.3u AS=0.057p AD=0.102p PS=0.68u PD=1.28u
M$897 VDD OUTP$80 VcascodeP$80 VDD sg13_lv_pmos L=0.13u W=0.3u AS=0.102p
+ AD=0.057p PS=1.28u PD=0.68u
M$898 VcascodeP$80 OUTN$80 C00|VbiasP[4]|VcascP|VcascP[1] VDD sg13_lv_pmos
+ L=0.13u W=0.3u AS=0.057p AD=0.102p PS=0.68u PD=1.28u
M$899 VDD OUTP$81 VcascodeP$81 VDD sg13_lv_pmos L=0.13u W=0.3u AS=0.102p
+ AD=0.057p PS=1.28u PD=0.68u
M$900 VcascodeP$81 OUTN$81 C00|VbiasP[4]|VcascP|VcascP[1] VDD sg13_lv_pmos
+ L=0.13u W=0.3u AS=0.057p AD=0.102p PS=0.68u PD=1.28u
M$901 VDD OUTP$82 VcascodeP$82 VDD sg13_lv_pmos L=0.13u W=0.3u AS=0.102p
+ AD=0.057p PS=1.28u PD=0.68u
M$902 VcascodeP$82 OUTN$82 C00|VbiasP[4]|VcascP|VcascP[1] VDD sg13_lv_pmos
+ L=0.13u W=0.3u AS=0.057p AD=0.102p PS=0.68u PD=1.28u
M$903 VDD OUTP$83 VcascodeP$83 VDD sg13_lv_pmos L=0.13u W=0.3u AS=0.102p
+ AD=0.057p PS=1.28u PD=0.68u
M$904 VcascodeP$83 OUTN$83 C00|VbiasP[4]|VcascP|VcascP[1] VDD sg13_lv_pmos
+ L=0.13u W=0.3u AS=0.057p AD=0.102p PS=0.68u PD=1.28u
M$905 VDD OUTP$84 VcascodeP$84 VDD sg13_lv_pmos L=0.13u W=0.3u AS=0.102p
+ AD=0.057p PS=1.28u PD=0.68u
M$906 VcascodeP$84 OUTN$84 C00|VbiasP[4]|VcascP|VcascP[1] VDD sg13_lv_pmos
+ L=0.13u W=0.3u AS=0.057p AD=0.102p PS=0.68u PD=1.28u
M$907 VDD OUTP$85 VcascodeP$85 VDD sg13_lv_pmos L=0.13u W=0.3u AS=0.102p
+ AD=0.057p PS=1.28u PD=0.68u
M$908 VcascodeP$85 OUTN$85 C00|VbiasP[4]|VcascP|VcascP[1] VDD sg13_lv_pmos
+ L=0.13u W=0.3u AS=0.057p AD=0.102p PS=0.68u PD=1.28u
M$909 VDD OUTP$86 VcascodeP$86 VDD sg13_lv_pmos L=0.13u W=0.3u AS=0.102p
+ AD=0.057p PS=1.28u PD=0.68u
M$910 VcascodeP$86 OUTN$86 C00|VbiasP[4]|VcascP|VcascP[1] VDD sg13_lv_pmos
+ L=0.13u W=0.3u AS=0.057p AD=0.102p PS=0.68u PD=1.28u
M$911 VDD OUTP$87 VcascodeP$87 VDD sg13_lv_pmos L=0.13u W=0.3u AS=0.102p
+ AD=0.057p PS=1.28u PD=0.68u
M$912 VcascodeP$87 OUTN$87 C00|VbiasP[4]|VcascP|VcascP[1] VDD sg13_lv_pmos
+ L=0.13u W=0.3u AS=0.057p AD=0.102p PS=0.68u PD=1.28u
M$913 VDD OUTP$88 VcascodeP$88 VDD sg13_lv_pmos L=0.13u W=0.3u AS=0.102p
+ AD=0.057p PS=1.28u PD=0.68u
M$914 VcascodeP$88 OUTN$88 C00|VbiasP[4]|VcascP|VcascP[1] VDD sg13_lv_pmos
+ L=0.13u W=0.3u AS=0.057p AD=0.102p PS=0.68u PD=1.28u
M$915 VDD OUTP$89 VcascodeP$89 VDD sg13_lv_pmos L=0.13u W=0.3u AS=0.102p
+ AD=0.057p PS=1.28u PD=0.68u
M$916 VcascodeP$89 OUTN$89 C00|VbiasP[4]|VcascP|VcascP[1] VDD sg13_lv_pmos
+ L=0.13u W=0.3u AS=0.057p AD=0.102p PS=0.68u PD=1.28u
M$917 VDD OUTP$90 VcascodeP$90 VDD sg13_lv_pmos L=0.13u W=0.3u AS=0.102p
+ AD=0.057p PS=1.28u PD=0.68u
M$918 VcascodeP$90 OUTN$90 C00|C20|VbiasP[5]|VcascP|VcascP[1] VDD sg13_lv_pmos
+ L=0.13u W=0.3u AS=0.057p AD=0.102p PS=0.68u PD=1.28u
M$919 VDD OUTP$91 VcascodeP$91 VDD sg13_lv_pmos L=0.13u W=0.3u AS=0.102p
+ AD=0.057p PS=1.28u PD=0.68u
M$920 VcascodeP$91 OUTN$91 C00|C20|VbiasP[5]|VcascP|VcascP[1] VDD sg13_lv_pmos
+ L=0.13u W=0.3u AS=0.057p AD=0.102p PS=0.68u PD=1.28u
M$921 VDD OUTP$92 VcascodeP$92 VDD sg13_lv_pmos L=0.13u W=0.3u AS=0.102p
+ AD=0.057p PS=1.28u PD=0.68u
M$922 VcascodeP$92 OUTN$92 C00|C20|VbiasP[5]|VcascP|VcascP[1] VDD sg13_lv_pmos
+ L=0.13u W=0.3u AS=0.057p AD=0.102p PS=0.68u PD=1.28u
M$923 VDD OUTP$93 VcascodeP$93 VDD sg13_lv_pmos L=0.13u W=0.3u AS=0.102p
+ AD=0.057p PS=1.28u PD=0.68u
M$924 VcascodeP$93 OUTN$93 C00|C20|VbiasP[5]|VcascP|VcascP[1] VDD sg13_lv_pmos
+ L=0.13u W=0.3u AS=0.057p AD=0.102p PS=0.68u PD=1.28u
M$925 VDD OUTP$94 VcascodeP$94 VDD sg13_lv_pmos L=0.13u W=0.3u AS=0.102p
+ AD=0.057p PS=1.28u PD=0.68u
M$926 VcascodeP$94 OUTN$94 C00|C20|VbiasP[5]|VcascP|VcascP[1] VDD sg13_lv_pmos
+ L=0.13u W=0.3u AS=0.057p AD=0.102p PS=0.68u PD=1.28u
M$927 VDD OUTP$95 VcascodeP$95 VDD sg13_lv_pmos L=0.13u W=0.3u AS=0.102p
+ AD=0.057p PS=1.28u PD=0.68u
M$928 VcascodeP$95 OUTN$95 C00|C20|VbiasP[5]|VcascP|VcascP[1] VDD sg13_lv_pmos
+ L=0.13u W=0.3u AS=0.057p AD=0.102p PS=0.68u PD=1.28u
M$929 VDD OUTP$96 VcascodeP$96 VDD sg13_lv_pmos L=0.13u W=0.3u AS=0.102p
+ AD=0.057p PS=1.28u PD=0.68u
M$930 VcascodeP$96 OUTN$96 C00|C20|VbiasP[5]|VcascP|VcascP[1] VDD sg13_lv_pmos
+ L=0.13u W=0.3u AS=0.057p AD=0.102p PS=0.68u PD=1.28u
M$931 VDD OUTP$97 VcascodeP$97 VDD sg13_lv_pmos L=0.13u W=0.3u AS=0.102p
+ AD=0.057p PS=1.28u PD=0.68u
M$932 VcascodeP$97 OUTN$97 C00|C20|VbiasP[5]|VcascP|VcascP[1] VDD sg13_lv_pmos
+ L=0.13u W=0.3u AS=0.057p AD=0.102p PS=0.68u PD=1.28u
M$933 VDD OUTP$98 VcascodeP$98 VDD sg13_lv_pmos L=0.13u W=0.3u AS=0.102p
+ AD=0.057p PS=1.28u PD=0.68u
M$934 VcascodeP$98 OUTN$98 C00|C20|VbiasP[5]|VcascP|VcascP[1] VDD sg13_lv_pmos
+ L=0.13u W=0.3u AS=0.057p AD=0.102p PS=0.68u PD=1.28u
M$935 VDD OUTP$99 VcascodeP$99 VDD sg13_lv_pmos L=0.13u W=0.3u AS=0.102p
+ AD=0.057p PS=1.28u PD=0.68u
M$936 VcascodeP$99 OUTN$99 C00|C20|VbiasP[5]|VcascP|VcascP[1] VDD sg13_lv_pmos
+ L=0.13u W=0.3u AS=0.057p AD=0.102p PS=0.68u PD=1.28u
M$937 VDD OUTP$100 VcascodeP$100 VDD sg13_lv_pmos L=0.13u W=0.3u AS=0.102p
+ AD=0.057p PS=1.28u PD=0.68u
M$938 VcascodeP$100 OUTN$100 C00|C20|VbiasP[5]|VcascP|VcascP[1] VDD
+ sg13_lv_pmos L=0.13u W=0.3u AS=0.057p AD=0.102p PS=0.68u PD=1.28u
M$939 VDD OUTP$101 VcascodeP$101 VDD sg13_lv_pmos L=0.13u W=0.3u AS=0.102p
+ AD=0.057p PS=1.28u PD=0.68u
M$940 VcascodeP$101 OUTN$101 C00|C20|VbiasP[5]|VcascP|VcascP[1] VDD
+ sg13_lv_pmos L=0.13u W=0.3u AS=0.057p AD=0.102p PS=0.68u PD=1.28u
M$941 VDD OUTP$102 VcascodeP$102 VDD sg13_lv_pmos L=0.13u W=0.3u AS=0.102p
+ AD=0.057p PS=1.28u PD=0.68u
M$942 VcascodeP$102 OUTN$102 C00|C20|VbiasP[5]|VcascP|VcascP[1] VDD
+ sg13_lv_pmos L=0.13u W=0.3u AS=0.057p AD=0.102p PS=0.68u PD=1.28u
M$943 VDD OUTP$103 VcascodeP$103 VDD sg13_lv_pmos L=0.13u W=0.3u AS=0.102p
+ AD=0.057p PS=1.28u PD=0.68u
M$944 VcascodeP$103 OUTN$103 C00|C20|VbiasP[5]|VcascP|VcascP[1] VDD
+ sg13_lv_pmos L=0.13u W=0.3u AS=0.057p AD=0.102p PS=0.68u PD=1.28u
M$945 VDD OUTP$104 VcascodeP$104 VDD sg13_lv_pmos L=0.13u W=0.3u AS=0.102p
+ AD=0.057p PS=1.28u PD=0.68u
M$946 VcascodeP$104 OUTN$104 C00|C20|VbiasP[5]|VcascP|VcascP[1] VDD
+ sg13_lv_pmos L=0.13u W=0.3u AS=0.057p AD=0.102p PS=0.68u PD=1.28u
M$947 VDD OUTP$105 VcascodeP$105 VDD sg13_lv_pmos L=0.13u W=0.3u AS=0.102p
+ AD=0.057p PS=1.28u PD=0.68u
M$948 VcascodeP$105 OUTN$105 C00|C20|VbiasP[5]|VcascP|VcascP[1] VDD
+ sg13_lv_pmos L=0.13u W=0.3u AS=0.057p AD=0.102p PS=0.68u PD=1.28u
M$949 VDD OUTP$106 VcascodeP$106 VDD sg13_lv_pmos L=0.13u W=0.3u AS=0.102p
+ AD=0.057p PS=1.28u PD=0.68u
M$950 VcascodeP$106 OUTN$106 C00|C20|VbiasP[5]|VcascP|VcascP[1] VDD
+ sg13_lv_pmos L=0.13u W=0.3u AS=0.057p AD=0.102p PS=0.68u PD=1.28u
M$951 VDD OUTP$107 VcascodeP$107 VDD sg13_lv_pmos L=0.13u W=0.3u AS=0.102p
+ AD=0.057p PS=1.28u PD=0.68u
M$952 VcascodeP$107 OUTN$107 C00|C20|VbiasP[5]|VcascP|VcascP[1] VDD
+ sg13_lv_pmos L=0.13u W=0.3u AS=0.057p AD=0.102p PS=0.68u PD=1.28u
M$953 VDD OUTP$108 VcascodeP$108 VDD sg13_lv_pmos L=0.13u W=0.3u AS=0.102p
+ AD=0.057p PS=1.28u PD=0.68u
M$954 VcascodeP$108 OUTN$108 C00|C20|VbiasP[6]|VcascP|VcascP[1] VDD
+ sg13_lv_pmos L=0.13u W=0.3u AS=0.057p AD=0.102p PS=0.68u PD=1.28u
M$955 VDD OUTP$109 VcascodeP$109 VDD sg13_lv_pmos L=0.13u W=0.3u AS=0.102p
+ AD=0.057p PS=1.28u PD=0.68u
M$956 VcascodeP$109 OUTN$109 C00|C20|VbiasP[6]|VcascP|VcascP[1] VDD
+ sg13_lv_pmos L=0.13u W=0.3u AS=0.057p AD=0.102p PS=0.68u PD=1.28u
M$957 VDD OUTP$110 VcascodeP$110 VDD sg13_lv_pmos L=0.13u W=0.3u AS=0.102p
+ AD=0.057p PS=1.28u PD=0.68u
M$958 VcascodeP$110 OUTN$110 C00|C20|VbiasP[6]|VcascP|VcascP[1] VDD
+ sg13_lv_pmos L=0.13u W=0.3u AS=0.057p AD=0.102p PS=0.68u PD=1.28u
M$959 VDD OUTP$111 VcascodeP$111 VDD sg13_lv_pmos L=0.13u W=0.3u AS=0.102p
+ AD=0.057p PS=1.28u PD=0.68u
M$960 VcascodeP$111 OUTN$111 C00|C20|VbiasP[6]|VcascP|VcascP[1] VDD
+ sg13_lv_pmos L=0.13u W=0.3u AS=0.057p AD=0.102p PS=0.68u PD=1.28u
M$961 VDD OUTP$112 VcascodeP$112 VDD sg13_lv_pmos L=0.13u W=0.3u AS=0.102p
+ AD=0.057p PS=1.28u PD=0.68u
M$962 VcascodeP$112 OUTN$112 C00|C20|VbiasP[6]|VcascP|VcascP[1] VDD
+ sg13_lv_pmos L=0.13u W=0.3u AS=0.057p AD=0.102p PS=0.68u PD=1.28u
M$963 VDD OUTP$113 VcascodeP$113 VDD sg13_lv_pmos L=0.13u W=0.3u AS=0.102p
+ AD=0.057p PS=1.28u PD=0.68u
M$964 VcascodeP$113 OUTN$113 C00|C20|VbiasP[6]|VcascP|VcascP[1] VDD
+ sg13_lv_pmos L=0.13u W=0.3u AS=0.057p AD=0.102p PS=0.68u PD=1.28u
M$965 VDD OUTP$114 VcascodeP$114 VDD sg13_lv_pmos L=0.13u W=0.3u AS=0.102p
+ AD=0.057p PS=1.28u PD=0.68u
M$966 VcascodeP$114 OUTN$114 C00|C20|VbiasP[6]|VcascP|VcascP[1] VDD
+ sg13_lv_pmos L=0.13u W=0.3u AS=0.057p AD=0.102p PS=0.68u PD=1.28u
M$967 VDD OUTP$115 VcascodeP$115 VDD sg13_lv_pmos L=0.13u W=0.3u AS=0.102p
+ AD=0.057p PS=1.28u PD=0.68u
M$968 VcascodeP$115 OUTN$115 C00|C20|VbiasP[6]|VcascP|VcascP[1] VDD
+ sg13_lv_pmos L=0.13u W=0.3u AS=0.057p AD=0.102p PS=0.68u PD=1.28u
M$969 VDD OUTP$116 VcascodeP$116 VDD sg13_lv_pmos L=0.13u W=0.3u AS=0.102p
+ AD=0.057p PS=1.28u PD=0.68u
M$970 VcascodeP$116 OUTN$116 C00|C20|VbiasP[6]|VcascP|VcascP[1] VDD
+ sg13_lv_pmos L=0.13u W=0.3u AS=0.057p AD=0.102p PS=0.68u PD=1.28u
M$971 VDD OUTP$117 VcascodeP$117 VDD sg13_lv_pmos L=0.13u W=0.3u AS=0.102p
+ AD=0.057p PS=1.28u PD=0.68u
M$972 VcascodeP$117 OUTN$117 C00|C20|VbiasP[6]|VcascP|VcascP[1] VDD
+ sg13_lv_pmos L=0.13u W=0.3u AS=0.057p AD=0.102p PS=0.68u PD=1.28u
M$973 VDD OUTP$118 VcascodeP$118 VDD sg13_lv_pmos L=0.13u W=0.3u AS=0.102p
+ AD=0.057p PS=1.28u PD=0.68u
M$974 VcascodeP$118 OUTN$118 C00|C20|VbiasP[6]|VcascP|VcascP[1] VDD
+ sg13_lv_pmos L=0.13u W=0.3u AS=0.057p AD=0.102p PS=0.68u PD=1.28u
M$975 VDD OUTP$119 VcascodeP$119 VDD sg13_lv_pmos L=0.13u W=0.3u AS=0.102p
+ AD=0.057p PS=1.28u PD=0.68u
M$976 VcascodeP$119 OUTN$119 C00|C20|VbiasP[6]|VcascP|VcascP[1] VDD
+ sg13_lv_pmos L=0.13u W=0.3u AS=0.057p AD=0.102p PS=0.68u PD=1.28u
M$977 VDD OUTP$120 VcascodeP$120 VDD sg13_lv_pmos L=0.13u W=0.3u AS=0.102p
+ AD=0.057p PS=1.28u PD=0.68u
M$978 VcascodeP$120 OUTN$120 C00|C20|VbiasP[6]|VcascP|VcascP[1] VDD
+ sg13_lv_pmos L=0.13u W=0.3u AS=0.057p AD=0.102p PS=0.68u PD=1.28u
M$979 VDD OUTP$121 VcascodeP$121 VDD sg13_lv_pmos L=0.13u W=0.3u AS=0.102p
+ AD=0.057p PS=1.28u PD=0.68u
M$980 VcascodeP$121 OUTN$121 C00|C20|VbiasP[6]|VcascP|VcascP[1] VDD
+ sg13_lv_pmos L=0.13u W=0.3u AS=0.057p AD=0.102p PS=0.68u PD=1.28u
M$981 VDD OUTP$122 VcascodeP$122 VDD sg13_lv_pmos L=0.13u W=0.3u AS=0.102p
+ AD=0.057p PS=1.28u PD=0.68u
M$982 VcascodeP$122 OUTN$122 C00|C20|VbiasP[6]|VcascP|VcascP[1] VDD
+ sg13_lv_pmos L=0.13u W=0.3u AS=0.057p AD=0.102p PS=0.68u PD=1.28u
M$983 VDD OUTP$123 VcascodeP$123 VDD sg13_lv_pmos L=0.13u W=0.3u AS=0.102p
+ AD=0.057p PS=1.28u PD=0.68u
M$984 VcascodeP$123 OUTN$123 C00|C20|VbiasP[6]|VcascP|VcascP[1] VDD
+ sg13_lv_pmos L=0.13u W=0.3u AS=0.057p AD=0.102p PS=0.68u PD=1.28u
M$985 VDD OUTP$124 VcascodeP$124 VDD sg13_lv_pmos L=0.13u W=0.3u AS=0.102p
+ AD=0.057p PS=1.28u PD=0.68u
M$986 VcascodeP$124 OUTN$124 C00|C20|VbiasP[6]|VcascP|VcascP[1] VDD
+ sg13_lv_pmos L=0.13u W=0.3u AS=0.057p AD=0.102p PS=0.68u PD=1.28u
M$987 VDD OUTP$125 VcascodeP$125 VDD sg13_lv_pmos L=0.13u W=0.3u AS=0.102p
+ AD=0.057p PS=1.28u PD=0.68u
M$988 VcascodeP$125 OUTN$125 C00|C20|VbiasP[6]|VcascP|VcascP[1] VDD
+ sg13_lv_pmos L=0.13u W=0.3u AS=0.057p AD=0.102p PS=0.68u PD=1.28u
M$989 VDD OUTP$126 VcascodeP$126 VDD sg13_lv_pmos L=0.13u W=0.3u AS=0.102p
+ AD=0.057p PS=1.28u PD=0.68u
M$990 VcascodeP$126 OUTN$126 C00|C20|VbiasP[7]|VcascP|VcascP[1] VDD
+ sg13_lv_pmos L=0.13u W=0.3u AS=0.057p AD=0.102p PS=0.68u PD=1.28u
M$991 VDD OUTP$127 VcascodeP$127 VDD sg13_lv_pmos L=0.13u W=0.3u AS=0.102p
+ AD=0.057p PS=1.28u PD=0.68u
M$992 VcascodeP$127 OUTN$127 C00|C20|VbiasP[7]|VcascP|VcascP[1] VDD
+ sg13_lv_pmos L=0.13u W=0.3u AS=0.057p AD=0.102p PS=0.68u PD=1.28u
M$993 VDD OUTP$128 VcascodeP$128 VDD sg13_lv_pmos L=0.13u W=0.3u AS=0.102p
+ AD=0.057p PS=1.28u PD=0.68u
M$994 VcascodeP$128 OUTN$128 C00|C20|VbiasP[7]|VcascP|VcascP[1] VDD
+ sg13_lv_pmos L=0.13u W=0.3u AS=0.057p AD=0.102p PS=0.68u PD=1.28u
M$995 VDD OUTP$129 VcascodeP$129 VDD sg13_lv_pmos L=0.13u W=0.3u AS=0.102p
+ AD=0.057p PS=1.28u PD=0.68u
M$996 VcascodeP$129 OUTN$129 C00|C20|VbiasP[7]|VcascP|VcascP[1] VDD
+ sg13_lv_pmos L=0.13u W=0.3u AS=0.057p AD=0.102p PS=0.68u PD=1.28u
M$997 VDD OUTP$130 VcascodeP$130 VDD sg13_lv_pmos L=0.13u W=0.3u AS=0.102p
+ AD=0.057p PS=1.28u PD=0.68u
M$998 VcascodeP$130 OUTN$130 C00|C20|VbiasP[7]|VcascP|VcascP[1] VDD
+ sg13_lv_pmos L=0.13u W=0.3u AS=0.057p AD=0.102p PS=0.68u PD=1.28u
M$999 VDD OUTP$131 VcascodeP$131 VDD sg13_lv_pmos L=0.13u W=0.3u AS=0.102p
+ AD=0.057p PS=1.28u PD=0.68u
M$1000 VcascodeP$131 OUTN$131 C00|C20|VbiasP[7]|VcascP|VcascP[1] VDD
+ sg13_lv_pmos L=0.13u W=0.3u AS=0.057p AD=0.102p PS=0.68u PD=1.28u
M$1001 VDD OUTP$132 VcascodeP$132 VDD sg13_lv_pmos L=0.13u W=0.3u AS=0.102p
+ AD=0.057p PS=1.28u PD=0.68u
M$1002 VcascodeP$132 OUTN$132 C00|C20|VbiasP[7]|VcascP|VcascP[1] VDD
+ sg13_lv_pmos L=0.13u W=0.3u AS=0.057p AD=0.102p PS=0.68u PD=1.28u
M$1003 VDD OUTP$133 VcascodeP$133 VDD sg13_lv_pmos L=0.13u W=0.3u AS=0.102p
+ AD=0.057p PS=1.28u PD=0.68u
M$1004 VcascodeP$133 OUTN$133 C00|C20|VbiasP[7]|VcascP|VcascP[1] VDD
+ sg13_lv_pmos L=0.13u W=0.3u AS=0.057p AD=0.102p PS=0.68u PD=1.28u
M$1005 VDD OUTP$134 VcascodeP$134 VDD sg13_lv_pmos L=0.13u W=0.3u AS=0.102p
+ AD=0.057p PS=1.28u PD=0.68u
M$1006 VcascodeP$134 OUTN$134 C00|C20|VbiasP[7]|VcascP|VcascP[1] VDD
+ sg13_lv_pmos L=0.13u W=0.3u AS=0.057p AD=0.102p PS=0.68u PD=1.28u
M$1007 VDD OUTP$135 VcascodeP$135 VDD sg13_lv_pmos L=0.13u W=0.3u AS=0.102p
+ AD=0.057p PS=1.28u PD=0.68u
M$1008 VcascodeP$135 OUTN$135 C00|C20|VbiasP[7]|VcascP|VcascP[1] VDD
+ sg13_lv_pmos L=0.13u W=0.3u AS=0.057p AD=0.102p PS=0.68u PD=1.28u
M$1009 VDD OUTP$136 VcascodeP$136 VDD sg13_lv_pmos L=0.13u W=0.3u AS=0.102p
+ AD=0.057p PS=1.28u PD=0.68u
M$1010 VcascodeP$136 OUTN$136 C00|C20|VbiasP[7]|VcascP|VcascP[1] VDD
+ sg13_lv_pmos L=0.13u W=0.3u AS=0.057p AD=0.102p PS=0.68u PD=1.28u
M$1011 VDD OUTP$137 VcascodeP$137 VDD sg13_lv_pmos L=0.13u W=0.3u AS=0.102p
+ AD=0.057p PS=1.28u PD=0.68u
M$1012 VcascodeP$137 OUTN$137 C00|C20|VbiasP[7]|VcascP|VcascP[1] VDD
+ sg13_lv_pmos L=0.13u W=0.3u AS=0.057p AD=0.102p PS=0.68u PD=1.28u
M$1013 VDD OUTP$138 VcascodeP$138 VDD sg13_lv_pmos L=0.13u W=0.3u AS=0.102p
+ AD=0.057p PS=1.28u PD=0.68u
M$1014 VcascodeP$138 OUTN$138 C00|C20|VbiasP[7]|VcascP|VcascP[1] VDD
+ sg13_lv_pmos L=0.13u W=0.3u AS=0.057p AD=0.102p PS=0.68u PD=1.28u
M$1015 VDD OUTP$139 VcascodeP$139 VDD sg13_lv_pmos L=0.13u W=0.3u AS=0.102p
+ AD=0.057p PS=1.28u PD=0.68u
M$1016 VcascodeP$139 OUTN$139 C00|C20|VbiasP[7]|VcascP|VcascP[1] VDD
+ sg13_lv_pmos L=0.13u W=0.3u AS=0.057p AD=0.102p PS=0.68u PD=1.28u
M$1017 VDD OUTP$140 VcascodeP$140 VDD sg13_lv_pmos L=0.13u W=0.3u AS=0.102p
+ AD=0.057p PS=1.28u PD=0.68u
M$1018 VcascodeP$140 OUTN$140 C00|C20|VbiasP[7]|VcascP|VcascP[1] VDD
+ sg13_lv_pmos L=0.13u W=0.3u AS=0.057p AD=0.102p PS=0.68u PD=1.28u
M$1019 VDD OUTP$141 VcascodeP$141 VDD sg13_lv_pmos L=0.13u W=0.3u AS=0.102p
+ AD=0.057p PS=1.28u PD=0.68u
M$1020 VcascodeP$141 OUTN$141 C00|C20|VbiasP[7]|VcascP|VcascP[1] VDD
+ sg13_lv_pmos L=0.13u W=0.3u AS=0.057p AD=0.102p PS=0.68u PD=1.28u
M$1021 VDD OUTP$142 VcascodeP$142 VDD sg13_lv_pmos L=0.13u W=0.3u AS=0.102p
+ AD=0.057p PS=1.28u PD=0.68u
M$1022 VcascodeP$142 OUTN$142 C00|C20|VbiasP[7]|VcascP|VcascP[1] VDD
+ sg13_lv_pmos L=0.13u W=0.3u AS=0.057p AD=0.102p PS=0.68u PD=1.28u
M$1023 VDD OUTP$143 VcascodeP$143 VDD sg13_lv_pmos L=0.13u W=0.3u AS=0.102p
+ AD=0.057p PS=1.28u PD=0.68u
M$1024 VcascodeP$143 OUTN$143 C00|C20|VbiasP[7]|VcascP|VcascP[1] VDD
+ sg13_lv_pmos L=0.13u W=0.3u AS=0.057p AD=0.102p PS=0.68u PD=1.28u
M$1025 OUTP$72 ENB[1]|ENB[3]|ENB[8]|INN|ONB VDD VDD sg13_lv_pmos L=0.13u W=0.3u
+ AS=0.1725p AD=0.057p PS=1.75u PD=0.68u
M$1026 VDD EN[1]|EN[3]|EN[8]|INP|ON OUTN$72 VDD sg13_lv_pmos L=0.13u W=0.3u
+ AS=0.057p AD=0.1725p PS=0.68u PD=1.75u
M$1027 OUTP$73 INN|ONB|ONB[15]|ONB[31]|ONB[64] VDD VDD sg13_lv_pmos L=0.13u
+ W=0.3u AS=0.1725p AD=0.057p PS=1.75u PD=0.68u
M$1028 VDD INP|ON|ON[15]|ON[31]|ON[64] OUTN$73 VDD sg13_lv_pmos L=0.13u W=0.3u
+ AS=0.057p AD=0.1725p PS=0.68u PD=1.75u
M$1029 OUTP$74 INN|ONB|ONB[14]|ONB[30]|ONB[65] VDD VDD sg13_lv_pmos L=0.13u
+ W=0.3u AS=0.1725p AD=0.057p PS=1.75u PD=0.68u
M$1030 VDD INP|ON|ON[14]|ON[30]|ON[65] OUTN$74 VDD sg13_lv_pmos L=0.13u W=0.3u
+ AS=0.057p AD=0.1725p PS=0.68u PD=1.75u
M$1031 OUTP$75 INN|ONB|ONB[13]|ONB[29]|ONB[66] VDD VDD sg13_lv_pmos L=0.13u
+ W=0.3u AS=0.1725p AD=0.057p PS=1.75u PD=0.68u
M$1032 VDD INP|ON|ON[13]|ON[29]|ON[66] OUTN$75 VDD sg13_lv_pmos L=0.13u W=0.3u
+ AS=0.057p AD=0.1725p PS=0.68u PD=1.75u
M$1033 OUTP$76 INN|ONB|ONB[12]|ONB[28]|ONB[67] VDD VDD sg13_lv_pmos L=0.13u
+ W=0.3u AS=0.1725p AD=0.057p PS=1.75u PD=0.68u
M$1034 VDD INP|ON|ON[12]|ON[28]|ON[67] OUTN$76 VDD sg13_lv_pmos L=0.13u W=0.3u
+ AS=0.057p AD=0.1725p PS=0.68u PD=1.75u
M$1035 OUTP$77 INN|ONB|ONB[11]|ONB[27]|ONB[68] VDD VDD sg13_lv_pmos L=0.13u
+ W=0.3u AS=0.1725p AD=0.057p PS=1.75u PD=0.68u
M$1036 VDD INP|ON|ON[11]|ON[27]|ON[68] OUTN$77 VDD sg13_lv_pmos L=0.13u W=0.3u
+ AS=0.057p AD=0.1725p PS=0.68u PD=1.75u
M$1037 OUTP$78 INN|ONB|ONB[10]|ONB[26]|ONB[69] VDD VDD sg13_lv_pmos L=0.13u
+ W=0.3u AS=0.1725p AD=0.057p PS=1.75u PD=0.68u
M$1038 VDD INP|ON|ON[10]|ON[26]|ON[69] OUTN$78 VDD sg13_lv_pmos L=0.13u W=0.3u
+ AS=0.057p AD=0.1725p PS=0.68u PD=1.75u
M$1039 OUTP$79 INN|ONB|ONB[25]|ONB[70]|ONB[9] VDD VDD sg13_lv_pmos L=0.13u
+ W=0.3u AS=0.1725p AD=0.057p PS=1.75u PD=0.68u
M$1040 VDD INP|ON|ON[25]|ON[70]|ON[9] OUTN$79 VDD sg13_lv_pmos L=0.13u W=0.3u
+ AS=0.057p AD=0.1725p PS=0.68u PD=1.75u
M$1041 OUTP$80 INN|ONB|ONB[24]|ONB[71]|ONB[8] VDD VDD sg13_lv_pmos L=0.13u
+ W=0.3u AS=0.1725p AD=0.057p PS=1.75u PD=0.68u
M$1042 VDD INP|ON|ON[24]|ON[71]|ON[8] OUTN$80 VDD sg13_lv_pmos L=0.13u W=0.3u
+ AS=0.057p AD=0.1725p PS=0.68u PD=1.75u
M$1043 OUTP$81 INN|ONB|ONB[23]|ONB[72]|ONB[7] VDD VDD sg13_lv_pmos L=0.13u
+ W=0.3u AS=0.1725p AD=0.057p PS=1.75u PD=0.68u
M$1044 VDD INP|ON|ON[23]|ON[72]|ON[7] OUTN$81 VDD sg13_lv_pmos L=0.13u W=0.3u
+ AS=0.057p AD=0.1725p PS=0.68u PD=1.75u
M$1045 OUTP$82 INN|ONB|ONB[22]|ONB[6]|ONB[73] VDD VDD sg13_lv_pmos L=0.13u
+ W=0.3u AS=0.1725p AD=0.057p PS=1.75u PD=0.68u
M$1046 VDD INP|ON|ON[22]|ON[6]|ON[73] OUTN$82 VDD sg13_lv_pmos L=0.13u W=0.3u
+ AS=0.057p AD=0.1725p PS=0.68u PD=1.75u
M$1047 OUTP$83 INN|ONB|ONB[21]|ONB[5]|ONB[74] VDD VDD sg13_lv_pmos L=0.13u
+ W=0.3u AS=0.1725p AD=0.057p PS=1.75u PD=0.68u
M$1048 VDD INP|ON|ON[21]|ON[5]|ON[74] OUTN$83 VDD sg13_lv_pmos L=0.13u W=0.3u
+ AS=0.057p AD=0.1725p PS=0.68u PD=1.75u
M$1049 OUTP$84 INN|ONB|ONB[20]|ONB[4]|ONB[75] VDD VDD sg13_lv_pmos L=0.13u
+ W=0.3u AS=0.1725p AD=0.057p PS=1.75u PD=0.68u
M$1050 VDD INP|ON|ON[20]|ON[4]|ON[75] OUTN$84 VDD sg13_lv_pmos L=0.13u W=0.3u
+ AS=0.057p AD=0.1725p PS=0.68u PD=1.75u
M$1051 OUTP$85 INN|ONB|ONB[19]|ONB[3]|ONB[76] VDD VDD sg13_lv_pmos L=0.13u
+ W=0.3u AS=0.1725p AD=0.057p PS=1.75u PD=0.68u
M$1052 VDD INP|ON|ON[19]|ON[3]|ON[76] OUTN$85 VDD sg13_lv_pmos L=0.13u W=0.3u
+ AS=0.057p AD=0.1725p PS=0.68u PD=1.75u
M$1053 OUTP$86 INN|ONB|ONB[18]|ONB[2]|ONB[77] VDD VDD sg13_lv_pmos L=0.13u
+ W=0.3u AS=0.1725p AD=0.057p PS=1.75u PD=0.68u
M$1054 VDD INP|ON|ON[18]|ON[2]|ON[77] OUTN$86 VDD sg13_lv_pmos L=0.13u W=0.3u
+ AS=0.057p AD=0.1725p PS=0.68u PD=1.75u
M$1055 OUTP$87 INN|ONB|ONB[17]|ONB[1]|ONB[78] VDD VDD sg13_lv_pmos L=0.13u
+ W=0.3u AS=0.1725p AD=0.057p PS=1.75u PD=0.68u
M$1056 VDD INP|ON|ON[17]|ON[1]|ON[78] OUTN$87 VDD sg13_lv_pmos L=0.13u W=0.3u
+ AS=0.057p AD=0.1725p PS=0.68u PD=1.75u
M$1057 OUTP$88 INN|ONB|ONB[0]|ONB[16]|ONB[79] VDD VDD sg13_lv_pmos L=0.13u
+ W=0.3u AS=0.1725p AD=0.057p PS=1.75u PD=0.68u
M$1058 VDD INP|ON|ON[0]|ON[16]|ON[79] OUTN$88 VDD sg13_lv_pmos L=0.13u W=0.3u
+ AS=0.057p AD=0.1725p PS=0.68u PD=1.75u
M$1059 OUTP$89 ENB[0]|ENB[2]|ENB[9]|INN|ONB VDD VDD sg13_lv_pmos L=0.13u W=0.3u
+ AS=0.1725p AD=0.057p PS=1.75u PD=0.68u
M$1060 VDD EN[0]|EN[2]|EN[9]|INP|ON OUTN$89 VDD sg13_lv_pmos L=0.13u W=0.3u
+ AS=0.057p AD=0.1725p PS=0.68u PD=1.75u
M$1061 OUTP$90 ENB[10]|ENB[1]|ENB[3]|INN|ONB VDD VDD sg13_lv_pmos L=0.13u
+ W=0.3u AS=0.1725p AD=0.057p PS=1.75u PD=0.68u
M$1062 VDD EN[10]|EN[1]|EN[3]|INP|ON OUTN$90 VDD sg13_lv_pmos L=0.13u W=0.3u
+ AS=0.057p AD=0.1725p PS=0.68u PD=1.75u
M$1063 OUTP$91 INN|ONB|ONB[15]|ONB[31]|ONB[80] VDD VDD sg13_lv_pmos L=0.13u
+ W=0.3u AS=0.1725p AD=0.057p PS=1.75u PD=0.68u
M$1064 VDD INP|ON|ON[15]|ON[31]|ON[80] OUTN$91 VDD sg13_lv_pmos L=0.13u W=0.3u
+ AS=0.057p AD=0.1725p PS=0.68u PD=1.75u
M$1065 OUTP$92 INN|ONB|ONB[14]|ONB[30]|ONB[81] VDD VDD sg13_lv_pmos L=0.13u
+ W=0.3u AS=0.1725p AD=0.057p PS=1.75u PD=0.68u
M$1066 VDD INP|ON|ON[14]|ON[30]|ON[81] OUTN$92 VDD sg13_lv_pmos L=0.13u W=0.3u
+ AS=0.057p AD=0.1725p PS=0.68u PD=1.75u
M$1067 OUTP$93 INN|ONB|ONB[13]|ONB[29]|ONB[82] VDD VDD sg13_lv_pmos L=0.13u
+ W=0.3u AS=0.1725p AD=0.057p PS=1.75u PD=0.68u
M$1068 VDD INP|ON|ON[13]|ON[29]|ON[82] OUTN$93 VDD sg13_lv_pmos L=0.13u W=0.3u
+ AS=0.057p AD=0.1725p PS=0.68u PD=1.75u
M$1069 OUTP$94 INN|ONB|ONB[12]|ONB[28]|ONB[83] VDD VDD sg13_lv_pmos L=0.13u
+ W=0.3u AS=0.1725p AD=0.057p PS=1.75u PD=0.68u
M$1070 VDD INP|ON|ON[12]|ON[28]|ON[83] OUTN$94 VDD sg13_lv_pmos L=0.13u W=0.3u
+ AS=0.057p AD=0.1725p PS=0.68u PD=1.75u
M$1071 OUTP$95 INN|ONB|ONB[11]|ONB[27]|ONB[84] VDD VDD sg13_lv_pmos L=0.13u
+ W=0.3u AS=0.1725p AD=0.057p PS=1.75u PD=0.68u
M$1072 VDD INP|ON|ON[11]|ON[27]|ON[84] OUTN$95 VDD sg13_lv_pmos L=0.13u W=0.3u
+ AS=0.057p AD=0.1725p PS=0.68u PD=1.75u
M$1073 OUTP$96 INN|ONB|ONB[10]|ONB[26]|ONB[85] VDD VDD sg13_lv_pmos L=0.13u
+ W=0.3u AS=0.1725p AD=0.057p PS=1.75u PD=0.68u
M$1074 VDD INP|ON|ON[10]|ON[26]|ON[85] OUTN$96 VDD sg13_lv_pmos L=0.13u W=0.3u
+ AS=0.057p AD=0.1725p PS=0.68u PD=1.75u
M$1075 OUTP$97 INN|ONB|ONB[25]|ONB[86]|ONB[9] VDD VDD sg13_lv_pmos L=0.13u
+ W=0.3u AS=0.1725p AD=0.057p PS=1.75u PD=0.68u
M$1076 VDD INP|ON|ON[25]|ON[86]|ON[9] OUTN$97 VDD sg13_lv_pmos L=0.13u W=0.3u
+ AS=0.057p AD=0.1725p PS=0.68u PD=1.75u
M$1077 OUTP$98 INN|ONB|ONB[24]|ONB[87]|ONB[8] VDD VDD sg13_lv_pmos L=0.13u
+ W=0.3u AS=0.1725p AD=0.057p PS=1.75u PD=0.68u
M$1078 VDD INP|ON|ON[24]|ON[87]|ON[8] OUTN$98 VDD sg13_lv_pmos L=0.13u W=0.3u
+ AS=0.057p AD=0.1725p PS=0.68u PD=1.75u
M$1079 OUTP$99 INN|ONB|ONB[23]|ONB[7]|ONB[88] VDD VDD sg13_lv_pmos L=0.13u
+ W=0.3u AS=0.1725p AD=0.057p PS=1.75u PD=0.68u
M$1080 VDD INP|ON|ON[23]|ON[7]|ON[88] OUTN$99 VDD sg13_lv_pmos L=0.13u W=0.3u
+ AS=0.057p AD=0.1725p PS=0.68u PD=1.75u
M$1081 OUTP$100 INN|ONB|ONB[22]|ONB[6]|ONB[89] VDD VDD sg13_lv_pmos L=0.13u
+ W=0.3u AS=0.1725p AD=0.057p PS=1.75u PD=0.68u
M$1082 VDD INP|ON|ON[22]|ON[6]|ON[89] OUTN$100 VDD sg13_lv_pmos L=0.13u W=0.3u
+ AS=0.057p AD=0.1725p PS=0.68u PD=1.75u
M$1083 OUTP$101 INN|ONB|ONB[21]|ONB[5]|ONB[90] VDD VDD sg13_lv_pmos L=0.13u
+ W=0.3u AS=0.1725p AD=0.057p PS=1.75u PD=0.68u
M$1084 VDD INP|ON|ON[21]|ON[5]|ON[90] OUTN$101 VDD sg13_lv_pmos L=0.13u W=0.3u
+ AS=0.057p AD=0.1725p PS=0.68u PD=1.75u
M$1085 OUTP$102 INN|ONB|ONB[20]|ONB[4]|ONB[91] VDD VDD sg13_lv_pmos L=0.13u
+ W=0.3u AS=0.1725p AD=0.057p PS=1.75u PD=0.68u
M$1086 VDD INP|ON|ON[20]|ON[4]|ON[91] OUTN$102 VDD sg13_lv_pmos L=0.13u W=0.3u
+ AS=0.057p AD=0.1725p PS=0.68u PD=1.75u
M$1087 OUTP$103 INN|ONB|ONB[19]|ONB[3]|ONB[92] VDD VDD sg13_lv_pmos L=0.13u
+ W=0.3u AS=0.1725p AD=0.057p PS=1.75u PD=0.68u
M$1088 VDD INP|ON|ON[19]|ON[3]|ON[92] OUTN$103 VDD sg13_lv_pmos L=0.13u W=0.3u
+ AS=0.057p AD=0.1725p PS=0.68u PD=1.75u
M$1089 OUTP$104 INN|ONB|ONB[18]|ONB[2]|ONB[93] VDD VDD sg13_lv_pmos L=0.13u
+ W=0.3u AS=0.1725p AD=0.057p PS=1.75u PD=0.68u
M$1090 VDD INP|ON|ON[18]|ON[2]|ON[93] OUTN$104 VDD sg13_lv_pmos L=0.13u W=0.3u
+ AS=0.057p AD=0.1725p PS=0.68u PD=1.75u
M$1091 OUTP$105 INN|ONB|ONB[17]|ONB[1]|ONB[94] VDD VDD sg13_lv_pmos L=0.13u
+ W=0.3u AS=0.1725p AD=0.057p PS=1.75u PD=0.68u
M$1092 VDD INP|ON|ON[17]|ON[1]|ON[94] OUTN$105 VDD sg13_lv_pmos L=0.13u W=0.3u
+ AS=0.057p AD=0.1725p PS=0.68u PD=1.75u
M$1093 OUTP$106 INN|ONB|ONB[0]|ONB[16]|ONB[95] VDD VDD sg13_lv_pmos L=0.13u
+ W=0.3u AS=0.1725p AD=0.057p PS=1.75u PD=0.68u
M$1094 VDD INP|ON|ON[0]|ON[16]|ON[95] OUTN$106 VDD sg13_lv_pmos L=0.13u W=0.3u
+ AS=0.057p AD=0.1725p PS=0.68u PD=1.75u
M$1095 OUTP$107 ENB[0]|ENB[11]|ENB[2]|INN|ONB VDD VDD sg13_lv_pmos L=0.13u
+ W=0.3u AS=0.1725p AD=0.057p PS=1.75u PD=0.68u
M$1096 VDD EN[0]|EN[11]|EN[2]|INP|ON OUTN$107 VDD sg13_lv_pmos L=0.13u W=0.3u
+ AS=0.057p AD=0.1725p PS=0.68u PD=1.75u
M$1097 OUTP$108 ENB[12]|ENB[1]|ENB[3]|INN|ONB VDD VDD sg13_lv_pmos L=0.13u
+ W=0.3u AS=0.1725p AD=0.057p PS=1.75u PD=0.68u
M$1098 VDD EN[12]|EN[1]|EN[3]|INP|ON OUTN$108 VDD sg13_lv_pmos L=0.13u W=0.3u
+ AS=0.057p AD=0.1725p PS=0.68u PD=1.75u
M$1099 OUTP$109 INN|ONB|ONB[15]|ONB[31]|ONB[96] VDD VDD sg13_lv_pmos L=0.13u
+ W=0.3u AS=0.1725p AD=0.057p PS=1.75u PD=0.68u
M$1100 VDD INP|ON|ON[15]|ON[31]|ON[96] OUTN$109 VDD sg13_lv_pmos L=0.13u W=0.3u
+ AS=0.057p AD=0.1725p PS=0.68u PD=1.75u
M$1101 OUTP$110 INN|ONB|ONB[14]|ONB[30]|ONB[97] VDD VDD sg13_lv_pmos L=0.13u
+ W=0.3u AS=0.1725p AD=0.057p PS=1.75u PD=0.68u
M$1102 VDD INP|ON|ON[14]|ON[30]|ON[97] OUTN$110 VDD sg13_lv_pmos L=0.13u W=0.3u
+ AS=0.057p AD=0.1725p PS=0.68u PD=1.75u
M$1103 OUTP$111 INN|ONB|ONB[13]|ONB[29]|ONB[98] VDD VDD sg13_lv_pmos L=0.13u
+ W=0.3u AS=0.1725p AD=0.057p PS=1.75u PD=0.68u
M$1104 VDD INP|ON|ON[13]|ON[29]|ON[98] OUTN$111 VDD sg13_lv_pmos L=0.13u W=0.3u
+ AS=0.057p AD=0.1725p PS=0.68u PD=1.75u
M$1105 OUTP$112 INN|ONB|ONB[12]|ONB[28]|ONB[99] VDD VDD sg13_lv_pmos L=0.13u
+ W=0.3u AS=0.1725p AD=0.057p PS=1.75u PD=0.68u
M$1106 VDD INP|ON|ON[12]|ON[28]|ON[99] OUTN$112 VDD sg13_lv_pmos L=0.13u W=0.3u
+ AS=0.057p AD=0.1725p PS=0.68u PD=1.75u
M$1107 OUTP$113 INN|ONB|ONB[100]|ONB[11]|ONB[27] VDD VDD sg13_lv_pmos L=0.13u
+ W=0.3u AS=0.1725p AD=0.057p PS=1.75u PD=0.68u
M$1108 VDD INP|ON|ON[100]|ON[11]|ON[27] OUTN$113 VDD sg13_lv_pmos L=0.13u
+ W=0.3u AS=0.057p AD=0.1725p PS=0.68u PD=1.75u
M$1109 OUTP$114 INN|ONB|ONB[101]|ONB[10]|ONB[26] VDD VDD sg13_lv_pmos L=0.13u
+ W=0.3u AS=0.1725p AD=0.057p PS=1.75u PD=0.68u
M$1110 VDD INP|ON|ON[101]|ON[10]|ON[26] OUTN$114 VDD sg13_lv_pmos L=0.13u
+ W=0.3u AS=0.057p AD=0.1725p PS=0.68u PD=1.75u
M$1111 OUTP$115 INN|ONB|ONB[102]|ONB[25]|ONB[9] VDD VDD sg13_lv_pmos L=0.13u
+ W=0.3u AS=0.1725p AD=0.057p PS=1.75u PD=0.68u
M$1112 VDD INP|ON|ON[102]|ON[25]|ON[9] OUTN$115 VDD sg13_lv_pmos L=0.13u W=0.3u
+ AS=0.057p AD=0.1725p PS=0.68u PD=1.75u
M$1113 OUTP$116 INN|ONB|ONB[103]|ONB[24]|ONB[8] VDD VDD sg13_lv_pmos L=0.13u
+ W=0.3u AS=0.1725p AD=0.057p PS=1.75u PD=0.68u
M$1114 VDD INP|ON|ON[103]|ON[24]|ON[8] OUTN$116 VDD sg13_lv_pmos L=0.13u W=0.3u
+ AS=0.057p AD=0.1725p PS=0.68u PD=1.75u
M$1115 OUTP$117 INN|ONB|ONB[104]|ONB[23]|ONB[7] VDD VDD sg13_lv_pmos L=0.13u
+ W=0.3u AS=0.1725p AD=0.057p PS=1.75u PD=0.68u
M$1116 VDD INP|ON|ON[104]|ON[23]|ON[7] OUTN$117 VDD sg13_lv_pmos L=0.13u W=0.3u
+ AS=0.057p AD=0.1725p PS=0.68u PD=1.75u
M$1117 OUTP$118 INN|ONB|ONB[105]|ONB[22]|ONB[6] VDD VDD sg13_lv_pmos L=0.13u
+ W=0.3u AS=0.1725p AD=0.057p PS=1.75u PD=0.68u
M$1118 VDD INP|ON|ON[105]|ON[22]|ON[6] OUTN$118 VDD sg13_lv_pmos L=0.13u W=0.3u
+ AS=0.057p AD=0.1725p PS=0.68u PD=1.75u
M$1119 OUTP$119 INN|ONB|ONB[106]|ONB[21]|ONB[5] VDD VDD sg13_lv_pmos L=0.13u
+ W=0.3u AS=0.1725p AD=0.057p PS=1.75u PD=0.68u
M$1120 VDD INP|ON|ON[106]|ON[21]|ON[5] OUTN$119 VDD sg13_lv_pmos L=0.13u W=0.3u
+ AS=0.057p AD=0.1725p PS=0.68u PD=1.75u
M$1121 OUTP$120 INN|ONB|ONB[107]|ONB[20]|ONB[4] VDD VDD sg13_lv_pmos L=0.13u
+ W=0.3u AS=0.1725p AD=0.057p PS=1.75u PD=0.68u
M$1122 VDD INP|ON|ON[107]|ON[20]|ON[4] OUTN$120 VDD sg13_lv_pmos L=0.13u W=0.3u
+ AS=0.057p AD=0.1725p PS=0.68u PD=1.75u
M$1123 OUTP$121 INN|ONB|ONB[108]|ONB[19]|ONB[3] VDD VDD sg13_lv_pmos L=0.13u
+ W=0.3u AS=0.1725p AD=0.057p PS=1.75u PD=0.68u
M$1124 VDD INP|ON|ON[108]|ON[19]|ON[3] OUTN$121 VDD sg13_lv_pmos L=0.13u W=0.3u
+ AS=0.057p AD=0.1725p PS=0.68u PD=1.75u
M$1125 OUTP$122 INN|ONB|ONB[109]|ONB[18]|ONB[2] VDD VDD sg13_lv_pmos L=0.13u
+ W=0.3u AS=0.1725p AD=0.057p PS=1.75u PD=0.68u
M$1126 VDD INP|ON|ON[109]|ON[18]|ON[2] OUTN$122 VDD sg13_lv_pmos L=0.13u W=0.3u
+ AS=0.057p AD=0.1725p PS=0.68u PD=1.75u
M$1127 OUTP$123 INN|ONB|ONB[110]|ONB[17]|ONB[1] VDD VDD sg13_lv_pmos L=0.13u
+ W=0.3u AS=0.1725p AD=0.057p PS=1.75u PD=0.68u
M$1128 VDD INP|ON|ON[110]|ON[17]|ON[1] OUTN$123 VDD sg13_lv_pmos L=0.13u W=0.3u
+ AS=0.057p AD=0.1725p PS=0.68u PD=1.75u
M$1129 OUTP$124 INN|ONB|ONB[0]|ONB[111]|ONB[16] VDD VDD sg13_lv_pmos L=0.13u
+ W=0.3u AS=0.1725p AD=0.057p PS=1.75u PD=0.68u
M$1130 VDD INP|ON|ON[0]|ON[111]|ON[16] OUTN$124 VDD sg13_lv_pmos L=0.13u W=0.3u
+ AS=0.057p AD=0.1725p PS=0.68u PD=1.75u
M$1131 OUTP$125 ENB[0]|ENB[13]|ENB[2]|INN|ONB VDD VDD sg13_lv_pmos L=0.13u
+ W=0.3u AS=0.1725p AD=0.057p PS=1.75u PD=0.68u
M$1132 VDD EN[0]|EN[13]|EN[2]|INP|ON OUTN$125 VDD sg13_lv_pmos L=0.13u W=0.3u
+ AS=0.057p AD=0.1725p PS=0.68u PD=1.75u
M$1133 OUTP$126 ENB[14]|ENB[1]|ENB[3]|INN|ONB VDD VDD sg13_lv_pmos L=0.13u
+ W=0.3u AS=0.1725p AD=0.057p PS=1.75u PD=0.68u
M$1134 VDD EN[14]|EN[1]|EN[3]|INP|ON OUTN$126 VDD sg13_lv_pmos L=0.13u W=0.3u
+ AS=0.057p AD=0.1725p PS=0.68u PD=1.75u
M$1135 OUTP$127 INN|ONB|ONB[112]|ONB[15]|ONB[31] VDD VDD sg13_lv_pmos L=0.13u
+ W=0.3u AS=0.1725p AD=0.057p PS=1.75u PD=0.68u
M$1136 VDD INP|ON|ON[112]|ON[15]|ON[31] OUTN$127 VDD sg13_lv_pmos L=0.13u
+ W=0.3u AS=0.057p AD=0.1725p PS=0.68u PD=1.75u
M$1137 OUTP$128 INN|ONB|ONB[113]|ONB[14]|ONB[30] VDD VDD sg13_lv_pmos L=0.13u
+ W=0.3u AS=0.1725p AD=0.057p PS=1.75u PD=0.68u
M$1138 VDD INP|ON|ON[113]|ON[14]|ON[30] OUTN$128 VDD sg13_lv_pmos L=0.13u
+ W=0.3u AS=0.057p AD=0.1725p PS=0.68u PD=1.75u
M$1139 OUTP$129 INN|ONB|ONB[114]|ONB[13]|ONB[29] VDD VDD sg13_lv_pmos L=0.13u
+ W=0.3u AS=0.1725p AD=0.057p PS=1.75u PD=0.68u
M$1140 VDD INP|ON|ON[114]|ON[13]|ON[29] OUTN$129 VDD sg13_lv_pmos L=0.13u
+ W=0.3u AS=0.057p AD=0.1725p PS=0.68u PD=1.75u
M$1141 OUTP$130 INN|ONB|ONB[115]|ONB[12]|ONB[28] VDD VDD sg13_lv_pmos L=0.13u
+ W=0.3u AS=0.1725p AD=0.057p PS=1.75u PD=0.68u
M$1142 VDD INP|ON|ON[115]|ON[12]|ON[28] OUTN$130 VDD sg13_lv_pmos L=0.13u
+ W=0.3u AS=0.057p AD=0.1725p PS=0.68u PD=1.75u
M$1143 OUTP$131 INN|ONB|ONB[116]|ONB[11]|ONB[27] VDD VDD sg13_lv_pmos L=0.13u
+ W=0.3u AS=0.1725p AD=0.057p PS=1.75u PD=0.68u
M$1144 VDD INP|ON|ON[116]|ON[11]|ON[27] OUTN$131 VDD sg13_lv_pmos L=0.13u
+ W=0.3u AS=0.057p AD=0.1725p PS=0.68u PD=1.75u
M$1145 OUTP$132 INN|ONB|ONB[10]|ONB[117]|ONB[26] VDD VDD sg13_lv_pmos L=0.13u
+ W=0.3u AS=0.1725p AD=0.057p PS=1.75u PD=0.68u
M$1146 VDD INP|ON|ON[10]|ON[117]|ON[26] OUTN$132 VDD sg13_lv_pmos L=0.13u
+ W=0.3u AS=0.057p AD=0.1725p PS=0.68u PD=1.75u
M$1147 OUTP$133 INN|ONB|ONB[118]|ONB[25]|ONB[9] VDD VDD sg13_lv_pmos L=0.13u
+ W=0.3u AS=0.1725p AD=0.057p PS=1.75u PD=0.68u
M$1148 VDD INP|ON|ON[118]|ON[25]|ON[9] OUTN$133 VDD sg13_lv_pmos L=0.13u W=0.3u
+ AS=0.057p AD=0.1725p PS=0.68u PD=1.75u
M$1149 OUTP$134 INN|ONB|ONB[119]|ONB[24]|ONB[8] VDD VDD sg13_lv_pmos L=0.13u
+ W=0.3u AS=0.1725p AD=0.057p PS=1.75u PD=0.68u
M$1150 VDD INP|ON|ON[119]|ON[24]|ON[8] OUTN$134 VDD sg13_lv_pmos L=0.13u W=0.3u
+ AS=0.057p AD=0.1725p PS=0.68u PD=1.75u
M$1151 OUTP$135 INN|ONB|ONB[120]|ONB[23]|ONB[7] VDD VDD sg13_lv_pmos L=0.13u
+ W=0.3u AS=0.1725p AD=0.057p PS=1.75u PD=0.68u
M$1152 VDD INP|ON|ON[120]|ON[23]|ON[7] OUTN$135 VDD sg13_lv_pmos L=0.13u W=0.3u
+ AS=0.057p AD=0.1725p PS=0.68u PD=1.75u
M$1153 OUTP$136 INN|ONB|ONB[121]|ONB[22]|ONB[6] VDD VDD sg13_lv_pmos L=0.13u
+ W=0.3u AS=0.1725p AD=0.057p PS=1.75u PD=0.68u
M$1154 VDD INP|ON|ON[121]|ON[22]|ON[6] OUTN$136 VDD sg13_lv_pmos L=0.13u W=0.3u
+ AS=0.057p AD=0.1725p PS=0.68u PD=1.75u
M$1155 OUTP$137 INN|ONB|ONB[122]|ONB[21]|ONB[5] VDD VDD sg13_lv_pmos L=0.13u
+ W=0.3u AS=0.1725p AD=0.057p PS=1.75u PD=0.68u
M$1156 VDD INP|ON|ON[122]|ON[21]|ON[5] OUTN$137 VDD sg13_lv_pmos L=0.13u W=0.3u
+ AS=0.057p AD=0.1725p PS=0.68u PD=1.75u
M$1157 OUTP$138 INN|ONB|ONB[123]|ONB[20]|ONB[4] VDD VDD sg13_lv_pmos L=0.13u
+ W=0.3u AS=0.1725p AD=0.057p PS=1.75u PD=0.68u
M$1158 VDD INP|ON|ON[123]|ON[20]|ON[4] OUTN$138 VDD sg13_lv_pmos L=0.13u W=0.3u
+ AS=0.057p AD=0.1725p PS=0.68u PD=1.75u
M$1159 OUTP$139 INN|ONB|ONB[124]|ONB[19]|ONB[3] VDD VDD sg13_lv_pmos L=0.13u
+ W=0.3u AS=0.1725p AD=0.057p PS=1.75u PD=0.68u
M$1160 VDD INP|ON|ON[124]|ON[19]|ON[3] OUTN$139 VDD sg13_lv_pmos L=0.13u W=0.3u
+ AS=0.057p AD=0.1725p PS=0.68u PD=1.75u
M$1161 OUTP$140 INN|ONB|ONB[125]|ONB[18]|ONB[2] VDD VDD sg13_lv_pmos L=0.13u
+ W=0.3u AS=0.1725p AD=0.057p PS=1.75u PD=0.68u
M$1162 VDD INP|ON|ON[125]|ON[18]|ON[2] OUTN$140 VDD sg13_lv_pmos L=0.13u W=0.3u
+ AS=0.057p AD=0.1725p PS=0.68u PD=1.75u
M$1163 OUTP$141 INN|ONB|ONB[126]|ONB[17]|ONB[1] VDD VDD sg13_lv_pmos L=0.13u
+ W=0.3u AS=0.1725p AD=0.057p PS=1.75u PD=0.68u
M$1164 VDD INP|ON|ON[126]|ON[17]|ON[1] OUTN$141 VDD sg13_lv_pmos L=0.13u W=0.3u
+ AS=0.057p AD=0.1725p PS=0.68u PD=1.75u
M$1165 OUTP$142 INN|ONB|ONB[0]|ONB[127]|ONB[16] VDD VDD sg13_lv_pmos L=0.13u
+ W=0.3u AS=0.1725p AD=0.057p PS=1.75u PD=0.68u
M$1166 VDD INP|ON|ON[0]|ON[127]|ON[16] OUTN$142 VDD sg13_lv_pmos L=0.13u W=0.3u
+ AS=0.057p AD=0.1725p PS=0.68u PD=1.75u
M$1167 OUTP$143 ENB[0]|ENB[15]|ENB[2]|INN|ONB VDD VDD sg13_lv_pmos L=0.13u
+ W=0.3u AS=0.1725p AD=0.057p PS=1.75u PD=0.68u
M$1168 VDD EN[0]|EN[15]|EN[2]|INP|ON OUTN$143 VDD sg13_lv_pmos L=0.13u W=0.3u
+ AS=0.057p AD=0.1725p PS=0.68u PD=1.75u
M$1169 VDD C10|VbiasP[3]|VcascP|VcascP[0] VDD VDD sg13_hv_pmos L=4.04u W=29.2u
+ AS=9.928p AD=9.928p PS=59.76u PD=59.76u
M$1171 VDD C10|C30|VbiasP[2]|VcascP|VcascP[0] VDD VDD sg13_hv_pmos L=4.04u
+ W=29.2u AS=9.928p AD=9.928p PS=59.76u PD=59.76u
M$1173 VDD C10|C30|VbiasP[1]|VcascP|VcascP[0] VDD VDD sg13_hv_pmos L=4.04u
+ W=29.2u AS=9.928p AD=9.928p PS=59.76u PD=59.76u
M$1175 VDD C10|C30|VbiasP[0]|VcascP|VcascP[0] VDD VDD sg13_hv_pmos L=4.04u
+ W=29.2u AS=9.928p AD=9.928p PS=59.76u PD=59.76u
M$1177 VDD C11|Iout|VbiasP|VbiasP[0] VDD VDD sg13_hv_pmos L=4.04u W=29.2u
+ AS=9.928p AD=9.928p PS=59.76u PD=59.76u
M$1179 VDD C11|C31|Iout|VbiasP|VbiasP[0] VDD VDD sg13_hv_pmos L=4.04u W=29.2u
+ AS=9.928p AD=9.928p PS=59.76u PD=59.76u
M$1181 VDD C11|C31|Iout|VbiasP|VbiasP[0]$1 VDD VDD sg13_hv_pmos L=4.04u W=29.2u
+ AS=9.928p AD=9.928p PS=59.76u PD=59.76u
M$1183 VDD C11|C31|Iout|VbiasP|VbiasP[0]$2 VDD VDD sg13_hv_pmos L=4.04u W=29.2u
+ AS=9.928p AD=9.928p PS=59.76u PD=59.76u
M$1185 VDD C01|Iout|VbiasP|VbiasP[1] VDD VDD sg13_hv_pmos L=4.04u W=29.2u
+ AS=9.928p AD=9.928p PS=59.76u PD=59.76u
M$1187 VDD C01|C21|Iout|VbiasP|VbiasP[1] VDD VDD sg13_hv_pmos L=4.04u W=29.2u
+ AS=9.928p AD=9.928p PS=59.76u PD=59.76u
M$1189 VDD C01|C21|Iout|VbiasP|VbiasP[1]$1 VDD VDD sg13_hv_pmos L=4.04u W=29.2u
+ AS=9.928p AD=9.928p PS=59.76u PD=59.76u
M$1191 VDD C01|C21|Iout|VbiasP|VbiasP[1]$2 VDD VDD sg13_hv_pmos L=4.04u W=29.2u
+ AS=9.928p AD=9.928p PS=59.76u PD=59.76u
M$1193 VDD C00|VbiasP[4]|VcascP|VcascP[1] VDD VDD sg13_hv_pmos L=4.04u W=29.2u
+ AS=9.928p AD=9.928p PS=59.76u PD=59.76u
M$1195 VDD C00|C20|VbiasP[5]|VcascP|VcascP[1] VDD VDD sg13_hv_pmos L=4.04u
+ W=29.2u AS=9.928p AD=9.928p PS=59.76u PD=59.76u
M$1197 VDD C00|C20|VbiasP[6]|VcascP|VcascP[1] VDD VDD sg13_hv_pmos L=4.04u
+ W=29.2u AS=9.928p AD=9.928p PS=59.76u PD=59.76u
M$1199 VDD C00|C20|VbiasP[7]|VcascP|VcascP[1] VDD VDD sg13_hv_pmos L=4.04u
+ W=29.2u AS=9.928p AD=9.928p PS=59.76u PD=59.76u
.ENDS dac4x32module
