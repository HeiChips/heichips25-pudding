** sch_path: /home/cmaier/EDA/PUDDING/xschem/test_nmirror.sch
**.subckt test_nmirror
XMsrc Vd Vg GND GND sg13_hv_nmos w=w l=l ng=1 m=1
XMref Vg Vg GND GND sg13_hv_nmos w=w l=l ng=1 m=1
Vprobe GND net1 0
.save i(vprobe)
G1 net1 Vg CUR=' 10**V(logI) '
VlogI logI GND {logI}
.save i(vlogi)
Vd Vd GND {vout}
.save i(vd)
**** begin user architecture code

.include sg13g2_stdcell.spice
.lib cornerMOSlv.lib mos_tt
.lib cornerMOShv.lib mos_tt

* device parameters
.param l      = 5u
.param w      = 5u
* instrumentation parameters
.param logI=-7
.param vout=0.6
* simulation parameters

.include test_nmirror.save
.temp=27
.options gmin=1e-15 abstol=1p method=gear
.options savecurrents
.control
save all
op
write test_nmirror.raw
set appendwrite
foreach l_val 0.5u 0.8u 1u 1.5u
  foreach w_val 2u 5u 10u 20u
    alterparam l = $l_val
    alterparam w = $w_val
    reset
    save all
    dc Vd 0 1.2 10m VlogI -8 -6 0.5
    write test_nmirror.raw
  end
end
plot Vg Vd
plot vprobe#branch 0-vd#branch
plot 2*(vprobe#branch+vd#branch)/(vprobe#branch-vd#branch)
.endc

**** end user architecture code
**.ends
.GLOBAL GND
.end
