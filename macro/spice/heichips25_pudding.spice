* NGSPICE file created from heichips25_pudding.ext - technology: ihp-sg13g2

* Black-box entry subcircuit for sg13g2_decap_8 abstract view
.subckt sg13g2_decap_8 VDD VSS
.ends

* Black-box entry subcircuit for sg13g2_fill_1 abstract view
.subckt sg13g2_fill_1 VDD VSS
.ends

* Black-box entry subcircuit for sg13g2_fill_2 abstract view
.subckt sg13g2_fill_2 VDD VSS
.ends

* Black-box entry subcircuit for sg13g2_dfrbpq_1 abstract view
.subckt sg13g2_dfrbpq_1 RESET_B VSS VDD D Q CLK
.ends

* Black-box entry subcircuit for sg13g2_buf_1 abstract view
.subckt sg13g2_buf_1 A X VDD VSS
.ends

* Black-box entry subcircuit for sg13g2_o21ai_1 abstract view
.subckt sg13g2_o21ai_1 B1 VDD Y VSS A1 A2
.ends

* Black-box entry subcircuit for sg13g2_buf_8 abstract view
.subckt sg13g2_buf_8 A X VDD VSS
.ends

* Black-box entry subcircuit for sg13g2_inv_1 abstract view
.subckt sg13g2_inv_1 VDD Y A VSS
.ends

* Black-box entry subcircuit for sg13g2_a21o_1 abstract view
.subckt sg13g2_a21o_1 A2 A1 B1 X VDD VSS
.ends

* Black-box entry subcircuit for sg13g2_a22oi_1 abstract view
.subckt sg13g2_a22oi_1 Y B1 B2 A2 A1 VDD VSS
.ends

* Black-box entry subcircuit for sg13g2_decap_4 abstract view
.subckt sg13g2_decap_4 VDD VSS
.ends

* Black-box entry subcircuit for sg13g2_a21oi_1 abstract view
.subckt sg13g2_a21oi_1 VSS VDD A1 A2 Y B1
.ends

* Black-box entry subcircuit for sg13g2_buf_16 abstract view
.subckt sg13g2_buf_16 X A VDD VSS
.ends

* Black-box entry subcircuit for sg13g2_or2_1 abstract view
.subckt sg13g2_or2_1 VSS VDD X B A
.ends

* Black-box entry subcircuit for sg13g2_nor2b_1 abstract view
.subckt sg13g2_nor2b_1 A B_N Y VDD VSS
.ends

* Black-box entry subcircuit for sg13g2_nand2_1 abstract view
.subckt sg13g2_nand2_1 Y A B VDD VSS
.ends

* Black-box entry subcircuit for sg13g2_nor2_1 abstract view
.subckt sg13g2_nor2_1 A B Y VDD VSS
.ends

* Black-box entry subcircuit for sg13g2_tiehi abstract view
.subckt sg13g2_tiehi VDD VSS L_HI
.ends

* Black-box entry subcircuit for analog_wires abstract view
.subckt analog_wires VcascP[0] VcascP[1] Iout[0] VDDA[0] VDDA[1] VbiasP[1] VbiasP[0]
+ VcascP[2] VcascP[3] Iout[1] VDDA[2] VDDA[3] VbiasP[3] VbiasP[2] i_in i_out
.ends

* Black-box entry subcircuit for dac32module abstract view
.subckt dac32module EN[1] ENB[1] EN[2] ENB[2] ON[16] ONB[16] ON[17] ONB[17] ON[18]
+ ONB[18] ON[19] ONB[19] ON[20] ONB[20] ON[21] ONB[21] ON[22] ONB[22] ON[23] ONB[23]
+ ON[24] ONB[24] ON[25] ONB[25] ON[26] ONB[26] ON[27] ONB[27] ON[28] ONB[28] ON[29]
+ ONB[29] ON[30] ONB[30] ON[31] ONB[31] EN[3] ENB[3] ON[0] ONB[0] ON[1] ONB[1] ON[2]
+ ONB[2] ON[3] ONB[3] ON[4] ONB[4] ON[5] ONB[5] ON[6] EN[0] ENB[0] ONB[6] ON[7] ONB[7]
+ ON[8] ONB[8] ON[9] ONB[9] ON[10] ONB[10] ON[11] ONB[11] ON[12] ONB[12] ON[13] ONB[13]
+ ON[14] ONB[14] ON[15] ONB[15] Iout VbiasP[0] VbiasP[1] VcascP[1] VcascP[0] VDD VSS
.ends

* Black-box entry subcircuit for sg13g2_antennanp abstract view
.subckt sg13g2_antennanp VDD VSS A
.ends

.subckt heichips25_pudding VGND VPWR clk ena i_in i_out rst_n ui_in[0] ui_in[1] ui_in[2]
+ ui_in[3] ui_in[4] ui_in[5] ui_in[6] ui_in[7] uio_in[0] uio_in[1] uio_in[2] uio_in[3]
+ uio_in[4] uio_in[5] uio_in[6] uio_in[7] uio_oe[0] uio_oe[1] uio_oe[2] uio_oe[3]
+ uio_oe[4] uio_oe[5] uio_oe[6] uio_oe[7] uio_out[0] uio_out[1] uio_out[2] uio_out[3]
+ uio_out[4] uio_out[5] uio_out[6] uio_out[7] uo_out[0] uo_out[1] uo_out[2] uo_out[3]
+ uo_out[4] uo_out[5] uo_out[6] uo_out[7]
XFILLER_27_406 VPWR VGND sg13g2_decap_8
XFILLER_39_266 VPWR VGND sg13g2_decap_8
XFILLER_10_328 VPWR VGND sg13g2_decap_8
XFILLER_22_111 VPWR VGND sg13g2_decap_8
XFILLER_22_188 VPWR VGND sg13g2_decap_8
XFILLER_23_612 VPWR VGND sg13g2_decap_8
XFILLER_35_494 VPWR VGND sg13g2_decap_8
XFILLER_7_7 VPWR VGND sg13g2_decap_8
XFILLER_13_122 VPWR VGND sg13g2_decap_8
XFILLER_14_601 VPWR VGND sg13g2_decap_8
XFILLER_14_612 VPWR VGND sg13g2_fill_1
XFILLER_14_634 VPWR VGND sg13g2_fill_2
XFILLER_18_428 VPWR VGND sg13g2_decap_8
XFILLER_26_85 VPWR VGND sg13g2_decap_8
XFILLER_41_420 VPWR VGND sg13g2_decap_8
XFILLER_45_203 VPWR VGND sg13g2_decap_8
XFILLER_13_199 VPWR VGND sg13g2_decap_8
XFILLER_41_497 VPWR VGND sg13g2_decap_8
XFILLER_42_84 VPWR VGND sg13g2_decap_8
XFILLER_9_137 VPWR VGND sg13g2_decap_8
XFILLER_1_560 VPWR VGND sg13g2_decap_8
XFILLER_5_354 VPWR VGND sg13g2_decap_8
XFILLER_36_258 VPWR VGND sg13g2_decap_8
XFILLER_37_704 VPWR VGND sg13g2_fill_1
XFILLER_3_67 VPWR VGND sg13g2_decap_8
XFILLER_49_564 VPWR VGND sg13g2_decap_8
XFILLER_17_483 VPWR VGND sg13g2_decap_8
XFILLER_32_442 VPWR VGND sg13g2_decap_8
XFILLER_44_280 VPWR VGND sg13g2_decap_8
XFILLER_20_659 VPWR VGND sg13g2_decap_8
X_0985_ net106 VGND VPWR _0145_ state\[17\] clknet_5_5__leaf_clk sg13g2_dfrbpq_1
XFILLER_8_181 VPWR VGND sg13g2_decap_8
XFILLER_28_704 VPWR VGND sg13g2_decap_8
Xfanout105 net108 net105 VPWR VGND sg13g2_buf_1
Xfanout116 net117 net116 VPWR VGND sg13g2_buf_1
XFILLER_27_203 VPWR VGND sg13g2_decap_8
XFILLER_35_291 VPWR VGND sg13g2_decap_8
XFILLER_42_217 VPWR VGND sg13g2_decap_8
XFILLER_10_125 VPWR VGND sg13g2_decap_8
XFILLER_23_486 VPWR VGND sg13g2_decap_8
XFILLER_7_619 VPWR VGND sg13g2_decap_8
XFILLER_7_608 VPWR VGND sg13g2_fill_1
XFILLER_12_76 VPWR VGND sg13g2_decap_8
XFILLER_2_368 VPWR VGND sg13g2_decap_8
XFILLER_5_4 VPWR VGND sg13g2_decap_8
XFILLER_18_225 VPWR VGND sg13g2_decap_8
XFILLER_37_40 VPWR VGND sg13g2_fill_2
XFILLER_46_567 VPWR VGND sg13g2_decap_8
XFILLER_14_475 VPWR VGND sg13g2_decap_8
XFILLER_42_762 VPWR VGND sg13g2_fill_2
XFILLER_42_784 VPWR VGND sg13g2_fill_2
XFILLER_41_294 VPWR VGND sg13g2_decap_8
X_0770_ _0409_ VPWR _0178_ VGND net95 _0009_ sg13g2_o21ai_1
XFILLER_5_151 VPWR VGND sg13g2_decap_8
XFILLER_17_280 VPWR VGND sg13g2_decap_8
XFILLER_24_239 VPWR VGND sg13g2_decap_8
XFILLER_49_361 VPWR VGND sg13g2_decap_8
XFILLER_20_456 VPWR VGND sg13g2_decap_8
X_0968_ net101 VGND VPWR _0128_ state\[0\] clknet_5_8__leaf_clk sg13g2_dfrbpq_1
Xclkbuf_4_12_0_clk clknet_0_clk clknet_4_12_0_clk VPWR VGND sg13g2_buf_8
X_0899_ VPWR _0249_ daisychain\[56\] VGND sg13g2_inv_1
XFILLER_28_501 VPWR VGND sg13g2_decap_8
XFILLER_23_283 VPWR VGND sg13g2_decap_8
XFILLER_28_578 VPWR VGND sg13g2_decap_8
XFILLER_43_504 VPWR VGND sg13g2_decap_8
XFILLER_23_31 VPWR VGND sg13g2_fill_2
XFILLER_3_611 VPWR VGND sg13g2_fill_2
XFILLER_7_427 VPWR VGND sg13g2_decap_8
XFILLER_2_165 VPWR VGND sg13g2_decap_8
XFILLER_0_35 VPWR VGND sg13g2_decap_8
XFILLER_19_567 VPWR VGND sg13g2_decap_8
XFILLER_34_537 VPWR VGND sg13g2_decap_8
XFILLER_46_364 VPWR VGND sg13g2_decap_8
XFILLER_47_821 VPWR VGND sg13g2_fill_2
XFILLER_14_272 VPWR VGND sg13g2_decap_8
XFILLER_15_784 VPWR VGND sg13g2_fill_1
XFILLER_42_581 VPWR VGND sg13g2_decap_8
X_0822_ VPWR _0041_ state\[18\] VGND sg13g2_inv_1
XFILLER_9_88 VPWR VGND sg13g2_decap_8
XFILLER_9_11 VPWR VGND sg13g2_decap_8
X_0753_ _0358_ VPWR _0161_ VGND net89 _0011_ sg13g2_o21ai_1
X_0684_ _0248_ net74 _0423_ _0424_ VPWR VGND sg13g2_a21o_1
XFILLER_6_460 VPWR VGND sg13g2_decap_8
XFILLER_37_342 VPWR VGND sg13g2_decap_8
XFILLER_12_209 VPWR VGND sg13g2_decap_8
XFILLER_25_526 VPWR VGND sg13g2_decap_8
XFILLER_40_518 VPWR VGND sg13g2_decap_8
XFILLER_20_253 VPWR VGND sg13g2_decap_8
XFILLER_16_526 VPWR VGND sg13g2_decap_8
XFILLER_18_64 VPWR VGND sg13g2_decap_8
XFILLER_28_375 VPWR VGND sg13g2_decap_8
XFILLER_43_301 VPWR VGND sg13g2_decap_8
XFILLER_11_242 VPWR VGND sg13g2_decap_8
XFILLER_12_710 VPWR VGND sg13g2_fill_1
XFILLER_24_592 VPWR VGND sg13g2_decap_8
XFILLER_31_529 VPWR VGND sg13g2_decap_8
XFILLER_34_96 VPWR VGND sg13g2_decap_8
XFILLER_43_378 VPWR VGND sg13g2_decap_8
XFILLER_3_452 VPWR VGND sg13g2_decap_8
XFILLER_7_224 VPWR VGND sg13g2_decap_8
XFILLER_38_139 VPWR VGND sg13g2_decap_8
XFILLER_19_364 VPWR VGND sg13g2_decap_8
XFILLER_34_334 VPWR VGND sg13g2_decap_8
XFILLER_46_161 VPWR VGND sg13g2_decap_8
XFILLER_47_651 VPWR VGND sg13g2_decap_8
X_1021_ net115 VGND VPWR _0181_ state\[53\] clknet_5_30__leaf_clk sg13g2_dfrbpq_1
X_0805_ VPWR _0202_ daisychain\[9\] VGND sg13g2_inv_1
X_0736_ _0307_ VPWR _0144_ VGND net85 _0039_ sg13g2_o21ai_1
X_0667_ net93 VPWR _0411_ VGND net71 state\[51\] sg13g2_o21ai_1
X_0598_ _0097_ _0358_ _0359_ net46 _0226_ VPWR VGND sg13g2_a22oi_1
XFILLER_25_323 VPWR VGND sg13g2_decap_8
XFILLER_29_139 VPWR VGND sg13g2_decap_8
XFILLER_13_518 VPWR VGND sg13g2_decap_8
XFILLER_21_540 VPWR VGND sg13g2_decap_8
XFILLER_40_315 VPWR VGND sg13g2_decap_8
XFILLER_5_706 VPWR VGND sg13g2_decap_4
XFILLER_4_249 VPWR VGND sg13g2_decap_8
XFILLER_0_455 VPWR VGND sg13g2_decap_8
XFILLER_29_41 VPWR VGND sg13g2_decap_8
XFILLER_48_448 VPWR VGND sg13g2_decap_8
XFILLER_16_323 VPWR VGND sg13g2_decap_8
XFILLER_28_172 VPWR VGND sg13g2_decap_8
XFILLER_31_326 VPWR VGND sg13g2_decap_8
XFILLER_35_109 VPWR VGND sg13g2_decap_8
XFILLER_43_175 VPWR VGND sg13g2_decap_8
XFILLER_44_665 VPWR VGND sg13g2_decap_8
XFILLER_45_84 VPWR VGND sg13g2_decap_8
X_0521_ VGND VPWR net26 daisychain\[13\] _0302_ net39 sg13g2_a21oi_1
X_0452_ VPWR _0019_ state\[59\] VGND sg13g2_inv_1
XFILLER_6_89 VPWR VGND sg13g2_decap_8
XFILLER_19_161 VPWR VGND sg13g2_decap_8
XFILLER_39_448 VPWR VGND sg13g2_decap_8
XFILLER_34_131 VPWR VGND sg13g2_decap_8
X_1004_ net109 VGND VPWR _0164_ state\[36\] clknet_5_27__leaf_clk sg13g2_dfrbpq_1
X_0719_ _0127_ _0449_ _0450_ net33 _0256_ VPWR VGND sg13g2_a22oi_1
XFILLER_13_304 VPWR VGND sg13g2_decap_8
XFILLER_25_120 VPWR VGND sg13g2_decap_8
XFILLER_26_610 VPWR VGND sg13g2_decap_8
XFILLER_26_665 VPWR VGND sg13g2_decap_8
XFILLER_26_698 VPWR VGND sg13g2_decap_4
XFILLER_38_492 VPWR VGND sg13g2_decap_4
XFILLER_41_602 VPWR VGND sg13g2_decap_8
XFILLER_15_76 VPWR VGND sg13g2_decap_8
XFILLER_25_197 VPWR VGND sg13g2_decap_8
XFILLER_31_53 VPWR VGND sg13g2_decap_8
XFILLER_40_112 VPWR VGND sg13g2_decap_8
XFILLER_40_189 VPWR VGND sg13g2_decap_8
XFILLER_9_319 VPWR VGND sg13g2_decap_8
Xoutput7 net7 uio_out[0] VPWR VGND sg13g2_buf_1
Xoutput20 net20 uo_out[5] VPWR VGND sg13g2_buf_1
XFILLER_5_536 VPWR VGND sg13g2_decap_4
XFILLER_0_252 VPWR VGND sg13g2_decap_8
XFILLER_49_746 VPWR VGND sg13g2_decap_8
XFILLER_48_245 VPWR VGND sg13g2_decap_8
XFILLER_16_120 VPWR VGND sg13g2_decap_8
XFILLER_16_197 VPWR VGND sg13g2_decap_8
XFILLER_17_665 VPWR VGND sg13g2_decap_4
XFILLER_17_676 VPWR VGND sg13g2_decap_8
XFILLER_31_123 VPWR VGND sg13g2_decap_8
XFILLER_44_462 VPWR VGND sg13g2_decap_8
XFILLER_12_370 VPWR VGND sg13g2_decap_8
Xclkbuf_5_17__f_clk clknet_5_17__leaf_clk clknet_4_8_0_clk VPWR VGND sg13g2_buf_16
XFILLER_8_363 VPWR VGND sg13g2_decap_8
X_0504_ _0203_ net61 _0288_ _0289_ VPWR VGND sg13g2_a21o_1
XFILLER_35_473 VPWR VGND sg13g2_decap_8
XFILLER_39_245 VPWR VGND sg13g2_decap_8
XFILLER_10_307 VPWR VGND sg13g2_decap_8
XFILLER_22_167 VPWR VGND sg13g2_decap_8
XFILLER_23_668 VPWR VGND sg13g2_fill_2
XFILLER_18_407 VPWR VGND sg13g2_decap_8
XFILLER_13_101 VPWR VGND sg13g2_decap_8
XFILLER_26_484 VPWR VGND sg13g2_decap_8
XFILLER_26_64 VPWR VGND sg13g2_decap_8
XFILLER_41_476 VPWR VGND sg13g2_decap_8
XFILLER_45_259 VPWR VGND sg13g2_decap_8
XFILLER_9_116 VPWR VGND sg13g2_decap_8
XFILLER_13_178 VPWR VGND sg13g2_decap_8
XFILLER_42_63 VPWR VGND sg13g2_decap_8
XFILLER_5_333 VPWR VGND sg13g2_decap_8
XFILLER_3_46 VPWR VGND sg13g2_decap_8
XFILLER_17_462 VPWR VGND sg13g2_decap_8
XFILLER_36_237 VPWR VGND sg13g2_decap_8
XFILLER_45_782 VPWR VGND sg13g2_fill_2
XFILLER_49_543 VPWR VGND sg13g2_decap_8
XFILLER_20_638 VPWR VGND sg13g2_decap_8
XFILLER_32_421 VPWR VGND sg13g2_decap_8
XFILLER_32_498 VPWR VGND sg13g2_decap_8
X_0984_ net106 VGND VPWR _0144_ state\[16\] clknet_5_5__leaf_clk sg13g2_dfrbpq_1
XFILLER_8_160 VPWR VGND sg13g2_decap_8
Xfanout106 net107 net106 VPWR VGND sg13g2_buf_1
Xfanout117 net118 net117 VPWR VGND sg13g2_buf_1
XFILLER_23_465 VPWR VGND sg13g2_decap_8
XFILLER_27_259 VPWR VGND sg13g2_decap_8
XFILLER_35_270 VPWR VGND sg13g2_decap_8
XFILLER_10_104 VPWR VGND sg13g2_decap_8
XFILLER_12_55 VPWR VGND sg13g2_decap_8
XFILLER_3_804 VPWR VGND sg13g2_fill_1
XFILLER_2_347 VPWR VGND sg13g2_decap_8
XFILLER_18_204 VPWR VGND sg13g2_decap_8
XFILLER_46_546 VPWR VGND sg13g2_decap_8
XFILLER_14_454 VPWR VGND sg13g2_decap_8
XFILLER_26_281 VPWR VGND sg13g2_decap_8
XFILLER_41_273 VPWR VGND sg13g2_decap_8
XFILLER_6_620 VPWR VGND sg13g2_decap_4
XFILLER_5_130 VPWR VGND sg13g2_decap_8
XFILLER_49_340 VPWR VGND sg13g2_decap_8
XFILLER_18_771 VPWR VGND sg13g2_decap_8
XFILLER_24_218 VPWR VGND sg13g2_decap_8
XFILLER_37_557 VPWR VGND sg13g2_decap_4
XFILLER_20_435 VPWR VGND sg13g2_decap_8
XFILLER_32_295 VPWR VGND sg13g2_decap_8
X_0967_ net98 VGND VPWR _0127_ daisychain\[63\] clknet_5_10__leaf_clk sg13g2_dfrbpq_1
XFILLER_9_480 VPWR VGND sg13g2_decap_8
X_0898_ VPWR _0016_ state\[56\] VGND sg13g2_inv_1
XFILLER_28_557 VPWR VGND sg13g2_decap_8
XFILLER_11_424 VPWR VGND sg13g2_fill_2
XFILLER_23_262 VPWR VGND sg13g2_decap_8
XFILLER_24_730 VPWR VGND sg13g2_decap_8
XFILLER_36_590 VPWR VGND sg13g2_decap_8
XFILLER_7_406 VPWR VGND sg13g2_decap_8
XFILLER_11_479 VPWR VGND sg13g2_decap_8
XFILLER_23_87 VPWR VGND sg13g2_decap_8
XFILLER_2_144 VPWR VGND sg13g2_decap_8
XFILLER_47_800 VPWR VGND sg13g2_decap_8
XFILLER_48_84 VPWR VGND sg13g2_decap_8
XFILLER_0_14 VPWR VGND sg13g2_decap_8
XFILLER_19_546 VPWR VGND sg13g2_decap_8
XFILLER_34_516 VPWR VGND sg13g2_decap_8
XFILLER_46_343 VPWR VGND sg13g2_decap_8
XFILLER_14_251 VPWR VGND sg13g2_decap_8
XFILLER_42_560 VPWR VGND sg13g2_decap_8
X_0821_ VPWR _0210_ daisychain\[17\] VGND sg13g2_inv_1
X_0752_ _0355_ VPWR _0160_ VGND net91 _0000_ sg13g2_o21ai_1
XFILLER_9_67 VPWR VGND sg13g2_decap_8
X_0683_ net89 VPWR _0423_ VGND net68 state\[55\] sg13g2_o21ai_1
XFILLER_25_505 VPWR VGND sg13g2_decap_8
XFILLER_37_321 VPWR VGND sg13g2_decap_8
XFILLER_20_232 VPWR VGND sg13g2_decap_8
XFILLER_37_398 VPWR VGND sg13g2_decap_8
XFILLER_0_615 VPWR VGND sg13g2_fill_2
XFILLER_0_637 VPWR VGND sg13g2_fill_1
XFILLER_29_822 VPWR VGND sg13g2_fill_1
XFILLER_16_505 VPWR VGND sg13g2_decap_8
XFILLER_18_43 VPWR VGND sg13g2_decap_8
XFILLER_28_354 VPWR VGND sg13g2_decap_8
XFILLER_31_508 VPWR VGND sg13g2_decap_8
XFILLER_43_357 VPWR VGND sg13g2_decap_8
XFILLER_11_221 VPWR VGND sg13g2_decap_8
XFILLER_11_298 VPWR VGND sg13g2_decap_8
XFILLER_24_571 VPWR VGND sg13g2_decap_8
XFILLER_34_75 VPWR VGND sg13g2_decap_8
XFILLER_7_203 VPWR VGND sg13g2_decap_8
XFILLER_3_431 VPWR VGND sg13g2_decap_8
XFILLER_19_343 VPWR VGND sg13g2_decap_8
XFILLER_38_118 VPWR VGND sg13g2_decap_8
XFILLER_46_140 VPWR VGND sg13g2_decap_8
XFILLER_47_630 VPWR VGND sg13g2_decap_8
X_1020_ net115 VGND VPWR _0180_ state\[52\] clknet_5_29__leaf_clk sg13g2_dfrbpq_1
Xclkbuf_4_11_0_clk clknet_0_clk clknet_4_11_0_clk VPWR VGND sg13g2_buf_8
XFILLER_34_313 VPWR VGND sg13g2_decap_8
XFILLER_30_585 VPWR VGND sg13g2_decap_8
X_0804_ VPWR _0063_ state\[9\] VGND sg13g2_inv_1
X_0735_ _0304_ VPWR _0143_ VGND net84 _0038_ sg13g2_o21ai_1
XFILLER_29_118 VPWR VGND sg13g2_decap_8
XFILLER_41_0 VPWR VGND sg13g2_decap_8
X_0666_ _0114_ _0409_ _0410_ net51 _0243_ VPWR VGND sg13g2_a22oi_1
X_0597_ VGND VPWR net27 daisychain\[32\] _0359_ net46 sg13g2_a21oi_1
XFILLER_25_302 VPWR VGND sg13g2_decap_8
XFILLER_37_195 VPWR VGND sg13g2_decap_8
XFILLER_38_674 VPWR VGND sg13g2_fill_2
XFILLER_21_596 VPWR VGND sg13g2_decap_8
XFILLER_25_379 VPWR VGND sg13g2_decap_8
XFILLER_20_99 VPWR VGND sg13g2_decap_8
XFILLER_4_228 VPWR VGND sg13g2_decap_8
XFILLER_0_434 VPWR VGND sg13g2_decap_8
XFILLER_29_20 VPWR VGND sg13g2_decap_8
XFILLER_29_97 VPWR VGND sg13g2_decap_8
XFILLER_48_427 VPWR VGND sg13g2_decap_8
XFILLER_16_302 VPWR VGND sg13g2_decap_8
XFILLER_16_379 VPWR VGND sg13g2_decap_8
XFILLER_28_151 VPWR VGND sg13g2_decap_8
XFILLER_31_305 VPWR VGND sg13g2_decap_8
XFILLER_43_154 VPWR VGND sg13g2_decap_8
XFILLER_44_644 VPWR VGND sg13g2_decap_8
XFILLER_45_63 VPWR VGND sg13g2_decap_8
XFILLER_12_585 VPWR VGND sg13g2_decap_8
XFILLER_8_578 VPWR VGND sg13g2_fill_1
XFILLER_8_556 VPWR VGND sg13g2_fill_2
XFILLER_8_545 VPWR VGND sg13g2_decap_8
X_0520_ _0207_ net62 _0300_ _0301_ VPWR VGND sg13g2_a21o_1
XFILLER_6_68 VPWR VGND sg13g2_decap_8
XFILLER_19_140 VPWR VGND sg13g2_decap_8
XFILLER_34_110 VPWR VGND sg13g2_decap_8
XFILLER_39_427 VPWR VGND sg13g2_decap_8
X_1003_ net112 VGND VPWR _0163_ state\[35\] clknet_5_18__leaf_clk sg13g2_dfrbpq_1
XFILLER_22_349 VPWR VGND sg13g2_decap_8
XFILLER_30_382 VPWR VGND sg13g2_decap_8
XFILLER_34_187 VPWR VGND sg13g2_decap_8
X_0718_ VGND VPWR net32 daisychain\[62\] _0450_ net33 sg13g2_a21oi_1
X_0649_ VGND VPWR net27 daisychain\[45\] _0398_ net48 sg13g2_a21oi_1
XFILLER_15_55 VPWR VGND sg13g2_decap_8
XFILLER_25_176 VPWR VGND sg13g2_decap_8
XFILLER_38_482 VPWR VGND sg13g2_decap_4
XFILLER_41_658 VPWR VGND sg13g2_fill_1
XFILLER_21_393 VPWR VGND sg13g2_decap_8
XFILLER_31_32 VPWR VGND sg13g2_decap_8
XFILLER_40_168 VPWR VGND sg13g2_decap_8
XFILLER_41_669 VPWR VGND sg13g2_decap_8
XFILLER_5_515 VPWR VGND sg13g2_decap_8
XFILLER_0_231 VPWR VGND sg13g2_decap_8
Xoutput8 net8 uio_out[1] VPWR VGND sg13g2_buf_1
Xoutput21 net21 uo_out[6] VPWR VGND sg13g2_buf_1
Xoutput10 net10 uio_out[3] VPWR VGND sg13g2_buf_1
XFILLER_49_725 VPWR VGND sg13g2_decap_8
XFILLER_17_644 VPWR VGND sg13g2_decap_8
XFILLER_29_482 VPWR VGND sg13g2_decap_8
XFILLER_36_419 VPWR VGND sg13g2_decap_8
XFILLER_44_441 VPWR VGND sg13g2_decap_8
XFILLER_48_224 VPWR VGND sg13g2_decap_8
XFILLER_16_176 VPWR VGND sg13g2_decap_8
XFILLER_31_102 VPWR VGND sg13g2_decap_8
XFILLER_31_179 VPWR VGND sg13g2_decap_8
XFILLER_32_603 VPWR VGND sg13g2_decap_8
XFILLER_8_342 VPWR VGND sg13g2_decap_8
XFILLER_39_224 VPWR VGND sg13g2_decap_8
X_0503_ net83 VPWR _0288_ VGND net61 state\[10\] sg13g2_o21ai_1
XFILLER_23_647 VPWR VGND sg13g2_decap_8
XFILLER_35_452 VPWR VGND sg13g2_decap_8
XFILLER_48_791 VPWR VGND sg13g2_decap_8
XFILLER_22_146 VPWR VGND sg13g2_decap_8
XFILLER_2_529 VPWR VGND sg13g2_decap_8
XFILLER_45_238 VPWR VGND sg13g2_decap_8
Xclkbuf_5_23__f_clk clknet_5_23__leaf_clk clknet_4_11_0_clk VPWR VGND sg13g2_buf_16
XFILLER_13_157 VPWR VGND sg13g2_decap_8
XFILLER_14_636 VPWR VGND sg13g2_fill_1
XFILLER_14_647 VPWR VGND sg13g2_decap_8
XFILLER_26_43 VPWR VGND sg13g2_decap_8
XFILLER_26_463 VPWR VGND sg13g2_decap_8
XFILLER_41_455 VPWR VGND sg13g2_decap_8
XFILLER_42_42 VPWR VGND sg13g2_decap_8
XFILLER_21_190 VPWR VGND sg13g2_decap_8
XFILLER_5_389 VPWR VGND sg13g2_decap_8
XFILLER_5_312 VPWR VGND sg13g2_decap_8
XFILLER_3_25 VPWR VGND sg13g2_decap_8
XFILLER_49_522 VPWR VGND sg13g2_decap_8
XFILLER_17_441 VPWR VGND sg13g2_decap_8
XFILLER_32_400 VPWR VGND sg13g2_decap_8
XFILLER_36_216 VPWR VGND sg13g2_decap_8
XFILLER_49_599 VPWR VGND sg13g2_decap_8
XFILLER_20_617 VPWR VGND sg13g2_decap_8
XFILLER_32_477 VPWR VGND sg13g2_decap_8
X_0983_ net108 VGND VPWR _0143_ state\[15\] clknet_5_0__leaf_clk sg13g2_dfrbpq_1
Xfanout107 net108 net107 VPWR VGND sg13g2_buf_1
Xfanout118 net119 net118 VPWR VGND sg13g2_buf_1
XFILLER_27_238 VPWR VGND sg13g2_decap_8
XFILLER_23_444 VPWR VGND sg13g2_decap_8
XFILLER_12_34 VPWR VGND sg13g2_decap_8
XFILLER_2_326 VPWR VGND sg13g2_decap_8
XFILLER_26_260 VPWR VGND sg13g2_decap_8
XFILLER_37_97 VPWR VGND sg13g2_decap_8
XFILLER_46_525 VPWR VGND sg13g2_decap_8
XFILLER_14_433 VPWR VGND sg13g2_decap_8
XFILLER_41_252 VPWR VGND sg13g2_decap_8
XFILLER_42_764 VPWR VGND sg13g2_fill_1
XFILLER_42_786 VPWR VGND sg13g2_fill_1
XFILLER_45_7 VPWR VGND sg13g2_decap_8
XFILLER_5_186 VPWR VGND sg13g2_decap_8
XFILLER_1_392 VPWR VGND sg13g2_decap_8
XFILLER_37_536 VPWR VGND sg13g2_decap_8
XFILLER_49_396 VPWR VGND sg13g2_decap_8
XFILLER_20_414 VPWR VGND sg13g2_decap_8
XFILLER_32_274 VPWR VGND sg13g2_decap_8
X_0897_ VPWR _0248_ daisychain\[55\] VGND sg13g2_inv_1
X_0966_ net98 VGND VPWR _0126_ daisychain\[62\] clknet_5_11__leaf_clk sg13g2_dfrbpq_1
XFILLER_0_808 VPWR VGND sg13g2_decap_8
XFILLER_28_536 VPWR VGND sg13g2_decap_8
XFILLER_43_539 VPWR VGND sg13g2_decap_8
XFILLER_11_403 VPWR VGND sg13g2_decap_8
XFILLER_11_447 VPWR VGND sg13g2_decap_8
XFILLER_23_11 VPWR VGND sg13g2_decap_4
XFILLER_23_241 VPWR VGND sg13g2_decap_8
XFILLER_23_33 VPWR VGND sg13g2_fill_1
XFILLER_23_66 VPWR VGND sg13g2_decap_8
XFILLER_2_123 VPWR VGND sg13g2_decap_8
XFILLER_3_635 VPWR VGND sg13g2_fill_2
XFILLER_19_525 VPWR VGND sg13g2_decap_8
XFILLER_46_322 VPWR VGND sg13g2_decap_8
XFILLER_48_63 VPWR VGND sg13g2_decap_8
XFILLER_14_230 VPWR VGND sg13g2_decap_8
XFILLER_15_775 VPWR VGND sg13g2_decap_8
XFILLER_46_399 VPWR VGND sg13g2_decap_8
XFILLER_30_767 VPWR VGND sg13g2_decap_8
X_0820_ VPWR _0040_ state\[17\] VGND sg13g2_inv_1
X_0751_ _0352_ VPWR _0159_ VGND net86 _0056_ sg13g2_o21ai_1
XFILLER_9_46 VPWR VGND sg13g2_decap_8
X_0682_ _0118_ _0421_ _0422_ net47 _0247_ VPWR VGND sg13g2_a22oi_1
XFILLER_6_495 VPWR VGND sg13g2_decap_8
XFILLER_37_300 VPWR VGND sg13g2_decap_8
XFILLER_37_377 VPWR VGND sg13g2_decap_8
XFILLER_49_193 VPWR VGND sg13g2_decap_8
XFILLER_20_211 VPWR VGND sg13g2_decap_8
XFILLER_21_701 VPWR VGND sg13g2_fill_2
XFILLER_33_594 VPWR VGND sg13g2_decap_8
XFILLER_20_288 VPWR VGND sg13g2_decap_8
X_0949_ net113 VGND VPWR _0109_ daisychain\[45\] clknet_5_16__leaf_clk sg13g2_dfrbpq_1
XFILLER_28_333 VPWR VGND sg13g2_decap_8
XFILLER_47_119 VPWR VGND sg13g2_decap_8
XFILLER_48_609 VPWR VGND sg13g2_decap_8
XFILLER_18_99 VPWR VGND sg13g2_decap_8
XFILLER_24_550 VPWR VGND sg13g2_decap_8
XFILLER_34_54 VPWR VGND sg13g2_decap_8
XFILLER_43_336 VPWR VGND sg13g2_decap_8
XFILLER_11_200 VPWR VGND sg13g2_decap_8
XFILLER_11_277 VPWR VGND sg13g2_decap_8
XFILLER_7_259 VPWR VGND sg13g2_decap_8
XFILLER_1_0 VPWR VGND sg13g2_decap_8
XFILLER_3_410 VPWR VGND sg13g2_decap_8
XFILLER_3_487 VPWR VGND sg13g2_decap_8
XFILLER_15_8 VPWR VGND sg13g2_fill_1
XFILLER_19_322 VPWR VGND sg13g2_decap_8
XFILLER_19_399 VPWR VGND sg13g2_decap_8
XFILLER_47_686 VPWR VGND sg13g2_decap_8
XFILLER_15_594 VPWR VGND sg13g2_decap_8
XFILLER_30_564 VPWR VGND sg13g2_decap_8
XFILLER_34_369 VPWR VGND sg13g2_decap_8
XFILLER_46_196 VPWR VGND sg13g2_decap_8
X_0803_ VPWR _0201_ daisychain\[8\] VGND sg13g2_inv_1
X_0734_ _0301_ VPWR _0142_ VGND net84 _0037_ sg13g2_o21ai_1
X_0665_ VGND VPWR net28 daisychain\[49\] _0410_ net51 sg13g2_a21oi_1
XFILLER_6_292 VPWR VGND sg13g2_decap_8
X_0596_ _0226_ net67 _0357_ _0358_ VPWR VGND sg13g2_a21o_1
XFILLER_1_91 VPWR VGND sg13g2_decap_8
XFILLER_25_358 VPWR VGND sg13g2_decap_8
XFILLER_37_174 VPWR VGND sg13g2_decap_8
XFILLER_38_653 VPWR VGND sg13g2_decap_8
Xclkbuf_5_4__f_clk clknet_5_4__leaf_clk clknet_4_2_0_clk VPWR VGND sg13g2_buf_16
XFILLER_21_575 VPWR VGND sg13g2_decap_8
XFILLER_33_391 VPWR VGND sg13g2_decap_8
XFILLER_0_413 VPWR VGND sg13g2_decap_8
XFILLER_20_23 VPWR VGND sg13g2_decap_4
XFILLER_20_78 VPWR VGND sg13g2_decap_8
XFILLER_4_207 VPWR VGND sg13g2_decap_8
XFILLER_17_804 VPWR VGND sg13g2_decap_8
XFILLER_28_130 VPWR VGND sg13g2_decap_8
XFILLER_29_76 VPWR VGND sg13g2_decap_8
XFILLER_44_623 VPWR VGND sg13g2_decap_8
XFILLER_48_406 VPWR VGND sg13g2_decap_8
XFILLER_12_564 VPWR VGND sg13g2_decap_8
XFILLER_16_358 VPWR VGND sg13g2_decap_8
XFILLER_32_807 VPWR VGND sg13g2_decap_4
XFILLER_43_133 VPWR VGND sg13g2_decap_8
XFILLER_45_42 VPWR VGND sg13g2_decap_8
XFILLER_8_524 VPWR VGND sg13g2_decap_8
XFILLER_6_47 VPWR VGND sg13g2_decap_8
XFILLER_6_25 VPWR VGND sg13g2_decap_4
XFILLER_39_406 VPWR VGND sg13g2_decap_8
XFILLER_3_284 VPWR VGND sg13g2_decap_8
XFILLER_19_196 VPWR VGND sg13g2_decap_8
XFILLER_34_166 VPWR VGND sg13g2_decap_8
XFILLER_47_483 VPWR VGND sg13g2_decap_8
X_1002_ net112 VGND VPWR _0162_ state\[34\] clknet_5_23__leaf_clk sg13g2_dfrbpq_1
XFILLER_15_391 VPWR VGND sg13g2_decap_8
XFILLER_22_328 VPWR VGND sg13g2_decap_8
XFILLER_30_361 VPWR VGND sg13g2_decap_8
X_0717_ _0256_ net55 _0448_ _0449_ VPWR VGND sg13g2_a21o_1
X_0648_ _0239_ net70 _0396_ _0397_ VPWR VGND sg13g2_a21o_1
XFILLER_38_461 VPWR VGND sg13g2_decap_8
X_0579_ net82 VPWR _0345_ VGND net60 state\[29\] sg13g2_o21ai_1
XFILLER_13_339 VPWR VGND sg13g2_decap_8
XFILLER_15_34 VPWR VGND sg13g2_decap_8
XFILLER_25_155 VPWR VGND sg13g2_decap_8
XFILLER_40_147 VPWR VGND sg13g2_decap_8
XFILLER_41_637 VPWR VGND sg13g2_decap_8
XFILLER_41_648 VPWR VGND sg13g2_fill_1
XFILLER_21_372 VPWR VGND sg13g2_decap_8
XFILLER_31_11 VPWR VGND sg13g2_decap_8
XFILLER_31_88 VPWR VGND sg13g2_decap_8
Xclkbuf_4_10_0_clk clknet_0_clk clknet_4_10_0_clk VPWR VGND sg13g2_buf_8
XFILLER_0_210 VPWR VGND sg13g2_decap_8
XFILLER_0_287 VPWR VGND sg13g2_decap_8
XFILLER_48_203 VPWR VGND sg13g2_decap_8
Xoutput9 net9 uio_out[2] VPWR VGND sg13g2_buf_1
Xoutput22 net22 uo_out[7] VPWR VGND sg13g2_buf_1
Xoutput11 net11 uio_out[4] VPWR VGND sg13g2_buf_1
XFILLER_49_704 VPWR VGND sg13g2_decap_8
XFILLER_16_155 VPWR VGND sg13g2_decap_8
XFILLER_17_623 VPWR VGND sg13g2_decap_8
XFILLER_29_461 VPWR VGND sg13g2_decap_8
XFILLER_44_420 VPWR VGND sg13g2_decap_8
XFILLER_31_158 VPWR VGND sg13g2_decap_8
XFILLER_44_497 VPWR VGND sg13g2_decap_8
XFILLER_8_321 VPWR VGND sg13g2_decap_8
X_0502_ _0073_ _0286_ _0287_ net39 _0202_ VPWR VGND sg13g2_a22oi_1
XFILLER_8_398 VPWR VGND sg13g2_decap_8
XFILLER_39_203 VPWR VGND sg13g2_decap_8
XFILLER_48_770 VPWR VGND sg13g2_decap_8
XFILLER_22_125 VPWR VGND sg13g2_decap_8
XFILLER_23_626 VPWR VGND sg13g2_decap_8
XFILLER_35_431 VPWR VGND sg13g2_decap_8
XFILLER_47_280 VPWR VGND sg13g2_decap_8
XFILLER_2_508 VPWR VGND sg13g2_decap_8
XFILLER_26_11 VPWR VGND sg13g2_decap_4
XFILLER_26_22 VPWR VGND sg13g2_decap_8
XFILLER_26_442 VPWR VGND sg13g2_decap_8
XFILLER_45_217 VPWR VGND sg13g2_decap_8
XFILLER_46_707 VPWR VGND sg13g2_decap_8
XFILLER_13_136 VPWR VGND sg13g2_decap_8
XFILLER_22_692 VPWR VGND sg13g2_decap_8
XFILLER_26_99 VPWR VGND sg13g2_decap_8
XFILLER_41_434 VPWR VGND sg13g2_decap_8
XFILLER_42_21 VPWR VGND sg13g2_decap_8
XFILLER_42_98 VPWR VGND sg13g2_decap_8
XFILLER_5_368 VPWR VGND sg13g2_decap_8
XFILLER_49_578 VPWR VGND sg13g2_decap_8
XFILLER_49_501 VPWR VGND sg13g2_decap_8
XFILLER_17_420 VPWR VGND sg13g2_decap_8
XFILLER_17_497 VPWR VGND sg13g2_decap_8
XFILLER_32_456 VPWR VGND sg13g2_decap_8
XFILLER_44_294 VPWR VGND sg13g2_decap_8
XFILLER_13_670 VPWR VGND sg13g2_fill_1
XFILLER_13_681 VPWR VGND sg13g2_decap_4
X_0982_ net108 VGND VPWR _0142_ state\[14\] clknet_5_0__leaf_clk sg13g2_dfrbpq_1
XFILLER_8_195 VPWR VGND sg13g2_decap_8
Xfanout108 net118 net108 VPWR VGND sg13g2_buf_1
Xfanout119 net1 net119 VPWR VGND sg13g2_buf_1
XFILLER_27_217 VPWR VGND sg13g2_decap_8
XFILLER_28_718 VPWR VGND sg13g2_fill_1
XFILLER_10_139 VPWR VGND sg13g2_decap_8
XFILLER_23_423 VPWR VGND sg13g2_decap_8
XFILLER_12_13 VPWR VGND sg13g2_decap_8
XFILLER_2_305 VPWR VGND sg13g2_decap_8
XFILLER_46_504 VPWR VGND sg13g2_decap_8
XFILLER_14_412 VPWR VGND sg13g2_decap_8
XFILLER_18_239 VPWR VGND sg13g2_decap_8
XFILLER_27_773 VPWR VGND sg13g2_decap_8
XFILLER_27_784 VPWR VGND sg13g2_fill_1
XFILLER_33_209 VPWR VGND sg13g2_decap_8
XFILLER_37_76 VPWR VGND sg13g2_decap_8
XFILLER_41_231 VPWR VGND sg13g2_decap_8
XFILLER_14_489 VPWR VGND sg13g2_decap_8
XFILLER_1_371 VPWR VGND sg13g2_decap_8
XFILLER_38_7 VPWR VGND sg13g2_decap_8
XFILLER_6_688 VPWR VGND sg13g2_decap_8
XFILLER_5_165 VPWR VGND sg13g2_decap_8
XFILLER_37_504 VPWR VGND sg13g2_decap_8
XFILLER_49_375 VPWR VGND sg13g2_decap_8
XFILLER_17_294 VPWR VGND sg13g2_decap_8
XFILLER_32_253 VPWR VGND sg13g2_decap_8
XFILLER_45_581 VPWR VGND sg13g2_decap_8
X_0896_ VPWR _0015_ state\[55\] VGND sg13g2_inv_1
X_0965_ net98 VGND VPWR _0125_ daisychain\[61\] clknet_5_11__leaf_clk sg13g2_dfrbpq_1
XFILLER_28_515 VPWR VGND sg13g2_decap_8
XFILLER_15_209 VPWR VGND sg13g2_decap_8
XFILLER_23_220 VPWR VGND sg13g2_decap_8
XFILLER_43_518 VPWR VGND sg13g2_decap_8
XFILLER_11_426 VPWR VGND sg13g2_fill_1
XFILLER_23_297 VPWR VGND sg13g2_decap_8
XFILLER_2_102 VPWR VGND sg13g2_decap_8
XFILLER_2_179 VPWR VGND sg13g2_decap_8
XFILLER_3_4 VPWR VGND sg13g2_decap_8
XFILLER_0_49 VPWR VGND sg13g2_decap_8
XFILLER_19_504 VPWR VGND sg13g2_decap_8
XFILLER_46_301 VPWR VGND sg13g2_decap_8
XFILLER_48_42 VPWR VGND sg13g2_decap_8
XFILLER_14_286 VPWR VGND sg13g2_decap_8
XFILLER_15_798 VPWR VGND sg13g2_fill_1
XFILLER_27_581 VPWR VGND sg13g2_decap_8
XFILLER_30_702 VPWR VGND sg13g2_fill_1
XFILLER_42_595 VPWR VGND sg13g2_decap_8
XFILLER_46_378 VPWR VGND sg13g2_decap_8
XFILLER_9_25 VPWR VGND sg13g2_decap_8
Xfanout90 net96 net90 VPWR VGND sg13g2_buf_1
X_0750_ _0349_ VPWR _0158_ VGND net82 _0055_ sg13g2_o21ai_1
X_0681_ VGND VPWR net29 daisychain\[53\] _0422_ net45 sg13g2_a21oi_1
XFILLER_6_474 VPWR VGND sg13g2_decap_8
XFILLER_37_356 VPWR VGND sg13g2_decap_8
XFILLER_49_172 VPWR VGND sg13g2_decap_8
XFILLER_20_267 VPWR VGND sg13g2_decap_8
XFILLER_33_573 VPWR VGND sg13g2_decap_8
X_0948_ net113 VGND VPWR _0108_ daisychain\[44\] clknet_5_20__leaf_clk sg13g2_dfrbpq_1
XFILLER_0_606 VPWR VGND sg13g2_fill_2
X_0879_ VPWR _0239_ daisychain\[46\] VGND sg13g2_inv_1
XFILLER_28_312 VPWR VGND sg13g2_decap_8
XFILLER_18_78 VPWR VGND sg13g2_decap_8
XFILLER_28_389 VPWR VGND sg13g2_decap_8
XFILLER_34_33 VPWR VGND sg13g2_decap_8
XFILLER_43_315 VPWR VGND sg13g2_decap_8
XFILLER_11_256 VPWR VGND sg13g2_decap_8
XFILLER_20_790 VPWR VGND sg13g2_fill_1
XFILLER_7_238 VPWR VGND sg13g2_decap_8
XFILLER_3_466 VPWR VGND sg13g2_decap_8
XFILLER_19_301 VPWR VGND sg13g2_decap_8
XFILLER_19_378 VPWR VGND sg13g2_decap_8
XFILLER_34_348 VPWR VGND sg13g2_decap_8
XFILLER_46_175 VPWR VGND sg13g2_decap_8
XFILLER_47_665 VPWR VGND sg13g2_decap_8
XFILLER_15_573 VPWR VGND sg13g2_decap_8
XFILLER_30_543 VPWR VGND sg13g2_decap_8
XFILLER_42_392 VPWR VGND sg13g2_decap_8
X_0802_ VPWR _0062_ state\[8\] VGND sg13g2_inv_1
X_0733_ _0298_ VPWR _0141_ VGND net83 _0036_ sg13g2_o21ai_1
X_0664_ _0243_ net73 _0408_ _0409_ VPWR VGND sg13g2_a21o_1
XFILLER_6_271 VPWR VGND sg13g2_decap_8
XFILLER_27_0 VPWR VGND sg13g2_decap_8
X_0595_ net88 VPWR _0357_ VGND net67 state\[33\] sg13g2_o21ai_1
XFILLER_1_70 VPWR VGND sg13g2_decap_8
XFILLER_25_337 VPWR VGND sg13g2_decap_8
XFILLER_33_370 VPWR VGND sg13g2_decap_8
XFILLER_37_153 VPWR VGND sg13g2_decap_8
XFILLER_38_676 VPWR VGND sg13g2_fill_1
XFILLER_40_329 VPWR VGND sg13g2_decap_8
XFILLER_20_13 VPWR VGND sg13g2_decap_8
XFILLER_21_554 VPWR VGND sg13g2_decap_8
XFILLER_0_469 VPWR VGND sg13g2_decap_8
XFILLER_16_337 VPWR VGND sg13g2_decap_8
XFILLER_28_186 VPWR VGND sg13g2_decap_8
XFILLER_29_55 VPWR VGND sg13g2_decap_8
XFILLER_29_643 VPWR VGND sg13g2_decap_8
XFILLER_29_687 VPWR VGND sg13g2_fill_2
XFILLER_43_112 VPWR VGND sg13g2_decap_8
XFILLER_44_602 VPWR VGND sg13g2_decap_8
XFILLER_45_21 VPWR VGND sg13g2_decap_8
Xdigitalen.g\[2\].u.inv1 VPWR digitalen.g\[2\].u.OUTN net6 VGND sg13g2_inv_1
XFILLER_12_543 VPWR VGND sg13g2_decap_8
XFILLER_32_819 VPWR VGND sg13g2_decap_4
XFILLER_43_189 VPWR VGND sg13g2_decap_8
XFILLER_44_679 VPWR VGND sg13g2_decap_8
XFILLER_45_98 VPWR VGND sg13g2_decap_8
XFILLER_8_503 VPWR VGND sg13g2_decap_8
XFILLER_3_263 VPWR VGND sg13g2_decap_8
XFILLER_8_569 VPWR VGND sg13g2_decap_8
XFILLER_10_90 VPWR VGND sg13g2_decap_8
XFILLER_15_370 VPWR VGND sg13g2_decap_8
XFILLER_19_175 VPWR VGND sg13g2_decap_8
XFILLER_22_307 VPWR VGND sg13g2_decap_8
XFILLER_23_808 VPWR VGND sg13g2_decap_8
XFILLER_34_145 VPWR VGND sg13g2_decap_8
XFILLER_47_462 VPWR VGND sg13g2_decap_8
X_1001_ net109 VGND VPWR _0161_ state\[33\] clknet_5_23__leaf_clk sg13g2_dfrbpq_1
XFILLER_30_340 VPWR VGND sg13g2_decap_8
X_0716_ net76 VPWR _0448_ VGND net55 state\[63\] sg13g2_o21ai_1
X_0647_ net92 VPWR _0396_ VGND net70 state\[46\] sg13g2_o21ai_1
X_0578_ _0092_ _0343_ _0344_ net38 _0221_ VPWR VGND sg13g2_a22oi_1
XFILLER_7_591 VPWR VGND sg13g2_decap_8
XFILLER_26_624 VPWR VGND sg13g2_fill_2
XFILLER_38_440 VPWR VGND sg13g2_decap_8
XFILLER_13_318 VPWR VGND sg13g2_decap_8
XFILLER_15_13 VPWR VGND sg13g2_fill_2
XFILLER_21_351 VPWR VGND sg13g2_decap_8
XFILLER_25_134 VPWR VGND sg13g2_decap_8
XFILLER_26_679 VPWR VGND sg13g2_decap_8
XFILLER_40_126 VPWR VGND sg13g2_decap_8
XFILLER_41_616 VPWR VGND sg13g2_decap_8
XFILLER_31_67 VPWR VGND sg13g2_decap_8
Xoutput12 net12 uio_out[5] VPWR VGND sg13g2_buf_1
XFILLER_0_266 VPWR VGND sg13g2_decap_8
XFILLER_29_440 VPWR VGND sg13g2_decap_8
XFILLER_48_259 VPWR VGND sg13g2_decap_8
XFILLER_16_134 VPWR VGND sg13g2_decap_8
XFILLER_17_602 VPWR VGND sg13g2_decap_8
XFILLER_44_476 VPWR VGND sg13g2_decap_8
XFILLER_31_137 VPWR VGND sg13g2_decap_8
XFILLER_8_377 VPWR VGND sg13g2_decap_8
XFILLER_8_300 VPWR VGND sg13g2_decap_8
X_0501_ VGND VPWR net23 daisychain\[8\] _0287_ net36 sg13g2_a21oi_1
XFILLER_35_410 VPWR VGND sg13g2_decap_8
XFILLER_39_259 VPWR VGND sg13g2_decap_8
XFILLER_22_104 VPWR VGND sg13g2_decap_8
XFILLER_23_605 VPWR VGND sg13g2_decap_8
XFILLER_35_487 VPWR VGND sg13g2_decap_8
XFILLER_7_91 VPWR VGND sg13g2_decap_8
XFILLER_13_115 VPWR VGND sg13g2_decap_8
XFILLER_14_627 VPWR VGND sg13g2_decap_8
XFILLER_26_421 VPWR VGND sg13g2_decap_8
XFILLER_26_498 VPWR VGND sg13g2_decap_8
XFILLER_26_78 VPWR VGND sg13g2_decap_8
XFILLER_41_413 VPWR VGND sg13g2_decap_8
XFILLER_22_671 VPWR VGND sg13g2_decap_8
XFILLER_42_77 VPWR VGND sg13g2_decap_8
XFILLER_1_553 VPWR VGND sg13g2_decap_8
XFILLER_5_347 VPWR VGND sg13g2_decap_8
XFILLER_49_557 VPWR VGND sg13g2_decap_8
XFILLER_17_476 VPWR VGND sg13g2_decap_8
XFILLER_32_435 VPWR VGND sg13g2_decap_8
XFILLER_44_273 VPWR VGND sg13g2_decap_8
X_0981_ net105 VGND VPWR _0141_ state\[13\] clknet_5_0__leaf_clk sg13g2_dfrbpq_1
XFILLER_12_181 VPWR VGND sg13g2_decap_8
XFILLER_40_490 VPWR VGND sg13g2_decap_8
XFILLER_8_174 VPWR VGND sg13g2_decap_8
Xfanout109 net112 net109 VPWR VGND sg13g2_buf_1
XFILLER_23_402 VPWR VGND sg13g2_decap_8
XFILLER_10_118 VPWR VGND sg13g2_decap_8
XFILLER_23_479 VPWR VGND sg13g2_decap_8
XFILLER_35_284 VPWR VGND sg13g2_decap_8
XFILLER_12_69 VPWR VGND sg13g2_decap_8
XFILLER_18_218 VPWR VGND sg13g2_decap_8
XFILLER_39_590 VPWR VGND sg13g2_decap_8
XFILLER_14_468 VPWR VGND sg13g2_decap_8
XFILLER_26_295 VPWR VGND sg13g2_decap_8
XFILLER_41_210 VPWR VGND sg13g2_decap_8
XFILLER_42_755 VPWR VGND sg13g2_decap_8
XFILLER_10_663 VPWR VGND sg13g2_fill_1
XFILLER_10_696 VPWR VGND sg13g2_fill_1
XFILLER_41_287 VPWR VGND sg13g2_decap_8
XFILLER_5_144 VPWR VGND sg13g2_decap_8
XFILLER_1_350 VPWR VGND sg13g2_decap_8
XFILLER_17_273 VPWR VGND sg13g2_decap_8
XFILLER_18_785 VPWR VGND sg13g2_fill_1
XFILLER_45_560 VPWR VGND sg13g2_decap_8
XFILLER_49_354 VPWR VGND sg13g2_decap_8
XFILLER_13_490 VPWR VGND sg13g2_decap_8
XFILLER_20_449 VPWR VGND sg13g2_decap_8
XFILLER_32_232 VPWR VGND sg13g2_decap_8
X_0964_ net119 VGND VPWR _0124_ daisychain\[60\] clknet_5_22__leaf_clk sg13g2_dfrbpq_1
X_0895_ VPWR _0247_ daisychain\[54\] VGND sg13g2_inv_1
XFILLER_9_494 VPWR VGND sg13g2_decap_8
XFILLER_4_81 VPWR VGND sg13g2_decap_8
XFILLER_23_24 VPWR VGND sg13g2_decap_8
XFILLER_23_276 VPWR VGND sg13g2_decap_8
XFILLER_2_158 VPWR VGND sg13g2_decap_8
XFILLER_3_604 VPWR VGND sg13g2_fill_2
XFILLER_48_21 VPWR VGND sg13g2_decap_8
XFILLER_0_28 VPWR VGND sg13g2_decap_8
XFILLER_27_560 VPWR VGND sg13g2_decap_8
XFILLER_46_357 VPWR VGND sg13g2_decap_8
XFILLER_47_814 VPWR VGND sg13g2_decap_8
XFILLER_48_98 VPWR VGND sg13g2_decap_8
XFILLER_14_265 VPWR VGND sg13g2_decap_8
XFILLER_15_744 VPWR VGND sg13g2_fill_1
XFILLER_15_755 VPWR VGND sg13g2_fill_2
XFILLER_42_574 VPWR VGND sg13g2_decap_8
Xfanout91 net95 net91 VPWR VGND sg13g2_buf_1
Xfanout80 net81 net80 VPWR VGND sg13g2_buf_1
XFILLER_10_482 VPWR VGND sg13g2_decap_8
X_0680_ _0247_ net68 _0420_ _0421_ VPWR VGND sg13g2_a21o_1
XFILLER_6_453 VPWR VGND sg13g2_decap_8
XFILLER_29_4 VPWR VGND sg13g2_decap_4
XFILLER_2_670 VPWR VGND sg13g2_fill_2
XFILLER_49_151 VPWR VGND sg13g2_decap_8
XFILLER_18_582 VPWR VGND sg13g2_decap_8
XFILLER_21_703 VPWR VGND sg13g2_fill_1
XFILLER_25_519 VPWR VGND sg13g2_decap_8
XFILLER_33_552 VPWR VGND sg13g2_decap_8
XFILLER_37_335 VPWR VGND sg13g2_decap_8
XFILLER_20_246 VPWR VGND sg13g2_decap_8
XFILLER_21_736 VPWR VGND sg13g2_decap_4
X_0947_ net114 VGND VPWR _0107_ daisychain\[43\] clknet_5_20__leaf_clk sg13g2_dfrbpq_1
XFILLER_9_291 VPWR VGND sg13g2_decap_8
X_0878_ VPWR _0005_ state\[46\] VGND sg13g2_inv_1
XFILLER_16_519 VPWR VGND sg13g2_decap_8
XFILLER_18_57 VPWR VGND sg13g2_decap_8
XFILLER_28_368 VPWR VGND sg13g2_decap_8
XFILLER_44_806 VPWR VGND sg13g2_fill_2
XFILLER_11_235 VPWR VGND sg13g2_decap_8
XFILLER_24_585 VPWR VGND sg13g2_decap_8
XFILLER_34_89 VPWR VGND sg13g2_decap_8
XFILLER_3_445 VPWR VGND sg13g2_decap_8
XFILLER_7_217 VPWR VGND sg13g2_decap_8
Xclkbuf_5_29__f_clk clknet_5_29__leaf_clk clknet_4_14_0_clk VPWR VGND sg13g2_buf_16
XFILLER_15_552 VPWR VGND sg13g2_decap_8
XFILLER_19_357 VPWR VGND sg13g2_decap_8
XFILLER_34_327 VPWR VGND sg13g2_decap_8
XFILLER_46_154 VPWR VGND sg13g2_decap_8
XFILLER_47_644 VPWR VGND sg13g2_decap_8
XFILLER_30_522 VPWR VGND sg13g2_decap_8
XFILLER_30_599 VPWR VGND sg13g2_decap_8
XFILLER_42_371 VPWR VGND sg13g2_decap_8
X_0801_ VPWR _0200_ daisychain\[7\] VGND sg13g2_inv_1
X_0732_ _0295_ VPWR _0140_ VGND net80 _0035_ sg13g2_o21ai_1
X_0663_ net94 VPWR _0408_ VGND net72 state\[50\] sg13g2_o21ai_1
X_0594_ _0096_ _0355_ _0356_ net49 _0225_ VPWR VGND sg13g2_a22oi_1
XFILLER_6_250 VPWR VGND sg13g2_decap_8
XFILLER_25_316 VPWR VGND sg13g2_decap_8
XFILLER_37_132 VPWR VGND sg13g2_decap_8
XFILLER_21_533 VPWR VGND sg13g2_decap_8
XFILLER_40_308 VPWR VGND sg13g2_decap_8
XFILLER_0_448 VPWR VGND sg13g2_decap_8
XFILLER_29_34 VPWR VGND sg13g2_decap_8
XFILLER_29_622 VPWR VGND sg13g2_decap_8
XFILLER_16_316 VPWR VGND sg13g2_decap_8
XFILLER_28_165 VPWR VGND sg13g2_decap_8
XFILLER_43_168 VPWR VGND sg13g2_decap_8
XFILLER_44_658 VPWR VGND sg13g2_decap_8
XFILLER_45_77 VPWR VGND sg13g2_decap_8
Xdigitalen.g\[2\].u.inv2 VPWR digitalen.g\[2\].u.OUTP digitalen.g\[2\].u.OUTN VGND
+ sg13g2_inv_1
XFILLER_12_522 VPWR VGND sg13g2_decap_8
XFILLER_24_393 VPWR VGND sg13g2_decap_8
XFILLER_31_319 VPWR VGND sg13g2_decap_8
XFILLER_3_242 VPWR VGND sg13g2_decap_8
XFILLER_4_710 VPWR VGND sg13g2_fill_1
XFILLER_19_154 VPWR VGND sg13g2_decap_8
XFILLER_20_8 VPWR VGND sg13g2_fill_1
XFILLER_47_441 VPWR VGND sg13g2_decap_8
X_1000_ net114 VGND VPWR _0160_ state\[32\] clknet_5_20__leaf_clk sg13g2_dfrbpq_1
XFILLER_34_124 VPWR VGND sg13g2_decap_8
XFILLER_30_396 VPWR VGND sg13g2_decap_8
X_0715_ _0126_ _0446_ _0447_ net33 _0255_ VPWR VGND sg13g2_a22oi_1
Xclkbuf_5_12__f_clk clknet_5_12__leaf_clk clknet_4_6_0_clk VPWR VGND sg13g2_buf_16
X_0646_ _0109_ _0394_ _0395_ net48 _0238_ VPWR VGND sg13g2_a22oi_1
X_0577_ VGND VPWR net24 daisychain\[27\] _0344_ net38 sg13g2_a21oi_1
XFILLER_25_113 VPWR VGND sg13g2_decap_8
XFILLER_26_603 VPWR VGND sg13g2_decap_8
XFILLER_26_658 VPWR VGND sg13g2_decap_8
XFILLER_15_69 VPWR VGND sg13g2_decap_8
XFILLER_21_330 VPWR VGND sg13g2_decap_8
XFILLER_40_105 VPWR VGND sg13g2_decap_8
XFILLER_31_46 VPWR VGND sg13g2_decap_8
Xoutput13 net13 uio_out[6] VPWR VGND sg13g2_buf_1
XFILLER_5_529 VPWR VGND sg13g2_decap_8
XFILLER_0_245 VPWR VGND sg13g2_decap_8
XFILLER_49_739 VPWR VGND sg13g2_decap_8
XFILLER_48_238 VPWR VGND sg13g2_decap_8
XFILLER_16_113 VPWR VGND sg13g2_decap_8
XFILLER_17_658 VPWR VGND sg13g2_decap_4
XFILLER_17_669 VPWR VGND sg13g2_fill_1
XFILLER_24_190 VPWR VGND sg13g2_decap_8
XFILLER_25_680 VPWR VGND sg13g2_fill_1
XFILLER_29_496 VPWR VGND sg13g2_decap_8
XFILLER_31_116 VPWR VGND sg13g2_decap_8
XFILLER_44_455 VPWR VGND sg13g2_decap_8
XFILLER_12_363 VPWR VGND sg13g2_decap_8
XFILLER_8_356 VPWR VGND sg13g2_decap_8
X_0500_ _0202_ net61 _0285_ _0286_ VPWR VGND sg13g2_a21o_1
XFILLER_11_4 VPWR VGND sg13g2_decap_8
XFILLER_35_466 VPWR VGND sg13g2_decap_8
XFILLER_39_238 VPWR VGND sg13g2_decap_8
XFILLER_16_691 VPWR VGND sg13g2_decap_8
XFILLER_31_650 VPWR VGND sg13g2_decap_8
XFILLER_31_661 VPWR VGND sg13g2_fill_2
XFILLER_30_193 VPWR VGND sg13g2_decap_8
XFILLER_7_70 VPWR VGND sg13g2_decap_8
X_0629_ VGND VPWR net27 daisychain\[40\] _0383_ net49 sg13g2_a21oi_1
XFILLER_26_400 VPWR VGND sg13g2_decap_8
XFILLER_26_477 VPWR VGND sg13g2_decap_8
XFILLER_26_57 VPWR VGND sg13g2_decap_8
XFILLER_38_293 VPWR VGND sg13g2_decap_8
XFILLER_22_650 VPWR VGND sg13g2_decap_8
XFILLER_41_469 VPWR VGND sg13g2_decap_8
XFILLER_42_56 VPWR VGND sg13g2_decap_8
XFILLER_9_109 VPWR VGND sg13g2_decap_8
XFILLER_5_326 VPWR VGND sg13g2_decap_8
XFILLER_1_532 VPWR VGND sg13g2_decap_8
XFILLER_3_39 VPWR VGND sg13g2_decap_8
XFILLER_17_455 VPWR VGND sg13g2_decap_8
XFILLER_29_293 VPWR VGND sg13g2_decap_8
XFILLER_49_536 VPWR VGND sg13g2_decap_8
XFILLER_12_160 VPWR VGND sg13g2_decap_8
XFILLER_32_414 VPWR VGND sg13g2_decap_8
XFILLER_44_252 VPWR VGND sg13g2_decap_8
X_0980_ net105 VGND VPWR _0140_ state\[12\] clknet_5_1__leaf_clk sg13g2_dfrbpq_1
XFILLER_8_153 VPWR VGND sg13g2_decap_8
XFILLER_35_263 VPWR VGND sg13g2_decap_8
XFILLER_12_48 VPWR VGND sg13g2_decap_8
XFILLER_23_458 VPWR VGND sg13g2_decap_8
XFILLER_31_480 VPWR VGND sg13g2_decap_8
XFILLER_3_808 VPWR VGND sg13g2_fill_1
XFILLER_3_819 VPWR VGND sg13g2_fill_1
XFILLER_19_709 VPWR VGND sg13g2_fill_1
XFILLER_46_539 VPWR VGND sg13g2_decap_8
XFILLER_14_447 VPWR VGND sg13g2_decap_8
XFILLER_26_274 VPWR VGND sg13g2_decap_8
XFILLER_41_266 VPWR VGND sg13g2_decap_8
XFILLER_6_624 VPWR VGND sg13g2_fill_2
XFILLER_5_123 VPWR VGND sg13g2_decap_8
XFILLER_49_333 VPWR VGND sg13g2_decap_8
XFILLER_17_252 VPWR VGND sg13g2_decap_8
XFILLER_18_731 VPWR VGND sg13g2_fill_2
XFILLER_18_797 VPWR VGND sg13g2_fill_2
XFILLER_32_211 VPWR VGND sg13g2_decap_8
XFILLER_20_428 VPWR VGND sg13g2_decap_8
XFILLER_32_288 VPWR VGND sg13g2_decap_8
X_0894_ VPWR _0014_ state\[54\] VGND sg13g2_inv_1
X_0963_ net119 VGND VPWR _0123_ daisychain\[59\] clknet_5_24__leaf_clk sg13g2_dfrbpq_1
XFILLER_9_473 VPWR VGND sg13g2_decap_8
XFILLER_4_60 VPWR VGND sg13g2_decap_8
XFILLER_11_417 VPWR VGND sg13g2_decap_8
XFILLER_23_255 VPWR VGND sg13g2_decap_8
XFILLER_24_723 VPWR VGND sg13g2_decap_8
XFILLER_36_583 VPWR VGND sg13g2_decap_8
XFILLER_2_137 VPWR VGND sg13g2_decap_8
XFILLER_19_539 VPWR VGND sg13g2_decap_8
XFILLER_34_509 VPWR VGND sg13g2_decap_8
XFILLER_46_336 VPWR VGND sg13g2_decap_8
XFILLER_48_77 VPWR VGND sg13g2_decap_8
XFILLER_10_461 VPWR VGND sg13g2_decap_8
XFILLER_14_244 VPWR VGND sg13g2_decap_8
XFILLER_42_553 VPWR VGND sg13g2_decap_8
Xfanout92 net95 net92 VPWR VGND sg13g2_buf_1
Xfanout81 net82 net81 VPWR VGND sg13g2_buf_1
Xfanout70 net73 net70 VPWR VGND sg13g2_buf_1
XFILLER_13_80 VPWR VGND sg13g2_decap_8
XFILLER_43_7 VPWR VGND sg13g2_decap_8
XFILLER_6_432 VPWR VGND sg13g2_decap_8
XFILLER_37_314 VPWR VGND sg13g2_decap_8
XFILLER_49_130 VPWR VGND sg13g2_decap_8
XFILLER_18_561 VPWR VGND sg13g2_decap_8
XFILLER_33_531 VPWR VGND sg13g2_decap_8
XFILLER_20_225 VPWR VGND sg13g2_decap_8
X_0877_ VPWR _0238_ daisychain\[45\] VGND sg13g2_inv_1
X_0946_ net114 VGND VPWR _0106_ daisychain\[42\] clknet_5_19__leaf_clk sg13g2_dfrbpq_1
XFILLER_9_270 VPWR VGND sg13g2_decap_8
XFILLER_18_36 VPWR VGND sg13g2_decap_8
XFILLER_28_347 VPWR VGND sg13g2_decap_8
XFILLER_11_214 VPWR VGND sg13g2_decap_8
XFILLER_24_564 VPWR VGND sg13g2_decap_8
XFILLER_34_68 VPWR VGND sg13g2_decap_8
XFILLER_36_391 VPWR VGND sg13g2_decap_8
XFILLER_3_424 VPWR VGND sg13g2_decap_8
XFILLER_19_336 VPWR VGND sg13g2_decap_8
XFILLER_46_133 VPWR VGND sg13g2_decap_8
XFILLER_47_623 VPWR VGND sg13g2_decap_8
XFILLER_15_531 VPWR VGND sg13g2_decap_8
XFILLER_30_501 VPWR VGND sg13g2_decap_8
XFILLER_34_306 VPWR VGND sg13g2_decap_8
XFILLER_42_350 VPWR VGND sg13g2_decap_8
XFILLER_30_578 VPWR VGND sg13g2_decap_8
X_0800_ VPWR _0061_ state\[7\] VGND sg13g2_inv_1
X_0731_ _0292_ VPWR _0139_ VGND net80 _0034_ sg13g2_o21ai_1
X_0662_ _0113_ _0406_ _0407_ net51 _0242_ VPWR VGND sg13g2_a22oi_1
X_0593_ VGND VPWR net27 daisychain\[31\] _0356_ net49 sg13g2_a21oi_1
XFILLER_37_111 VPWR VGND sg13g2_decap_8
XFILLER_37_188 VPWR VGND sg13g2_decap_8
XFILLER_38_667 VPWR VGND sg13g2_decap_8
XFILLER_21_512 VPWR VGND sg13g2_decap_8
XFILLER_21_589 VPWR VGND sg13g2_decap_8
X_0929_ net101 VGND VPWR _0089_ daisychain\[25\] clknet_5_9__leaf_clk sg13g2_dfrbpq_1
XFILLER_0_427 VPWR VGND sg13g2_decap_8
XFILLER_29_13 VPWR VGND sg13g2_decap_8
XFILLER_29_601 VPWR VGND sg13g2_decap_8
XFILLER_29_656 VPWR VGND sg13g2_decap_4
XFILLER_12_501 VPWR VGND sg13g2_decap_8
XFILLER_17_818 VPWR VGND sg13g2_decap_4
XFILLER_24_372 VPWR VGND sg13g2_decap_8
XFILLER_28_144 VPWR VGND sg13g2_decap_8
XFILLER_29_678 VPWR VGND sg13g2_decap_4
XFILLER_43_147 VPWR VGND sg13g2_decap_8
XFILLER_44_637 VPWR VGND sg13g2_decap_8
XFILLER_45_56 VPWR VGND sg13g2_decap_8
XFILLER_12_578 VPWR VGND sg13g2_decap_8
XFILLER_8_538 VPWR VGND sg13g2_decap_8
XFILLER_3_221 VPWR VGND sg13g2_decap_8
XFILLER_3_298 VPWR VGND sg13g2_decap_8
XFILLER_19_133 VPWR VGND sg13g2_decap_8
XFILLER_34_103 VPWR VGND sg13g2_decap_8
XFILLER_47_420 VPWR VGND sg13g2_decap_8
XFILLER_47_497 VPWR VGND sg13g2_decap_8
XFILLER_30_375 VPWR VGND sg13g2_decap_8
X_0714_ VGND VPWR net32 daisychain\[61\] _0447_ net33 sg13g2_a21oi_1
X_0645_ VGND VPWR net27 daisychain\[44\] _0395_ net48 sg13g2_a21oi_1
X_0576_ _0221_ net60 _0342_ _0343_ VPWR VGND sg13g2_a21o_1
XFILLER_15_48 VPWR VGND sg13g2_decap_8
XFILLER_25_169 VPWR VGND sg13g2_decap_8
XFILLER_38_475 VPWR VGND sg13g2_decap_8
XFILLER_38_486 VPWR VGND sg13g2_fill_1
XFILLER_21_386 VPWR VGND sg13g2_decap_8
XFILLER_31_25 VPWR VGND sg13g2_decap_8
XFILLER_5_508 VPWR VGND sg13g2_decap_8
XFILLER_0_224 VPWR VGND sg13g2_decap_8
XFILLER_1_747 VPWR VGND sg13g2_fill_2
Xoutput14 net14 uio_out[7] VPWR VGND sg13g2_buf_1
XFILLER_17_637 VPWR VGND sg13g2_decap_8
XFILLER_29_475 VPWR VGND sg13g2_decap_8
XFILLER_48_217 VPWR VGND sg13g2_decap_8
XFILLER_49_718 VPWR VGND sg13g2_decap_8
XFILLER_12_342 VPWR VGND sg13g2_decap_8
XFILLER_16_169 VPWR VGND sg13g2_decap_8
XFILLER_44_434 VPWR VGND sg13g2_decap_8
XFILLER_8_335 VPWR VGND sg13g2_decap_8
XFILLER_39_217 VPWR VGND sg13g2_decap_8
XFILLER_35_445 VPWR VGND sg13g2_decap_8
XFILLER_47_294 VPWR VGND sg13g2_decap_8
XFILLER_48_784 VPWR VGND sg13g2_decap_8
XFILLER_22_139 VPWR VGND sg13g2_decap_8
XFILLER_30_172 VPWR VGND sg13g2_decap_8
XFILLER_31_695 VPWR VGND sg13g2_fill_2
X_0628_ _0234_ net69 _0381_ _0382_ VPWR VGND sg13g2_a21o_1
XFILLER_38_272 VPWR VGND sg13g2_decap_8
XFILLER_39_740 VPWR VGND sg13g2_fill_1
X_0559_ net83 VPWR _0330_ VGND net58 state\[24\] sg13g2_o21ai_1
XFILLER_26_36 VPWR VGND sg13g2_decap_8
XFILLER_26_456 VPWR VGND sg13g2_decap_8
XFILLER_41_448 VPWR VGND sg13g2_decap_8
XFILLER_42_35 VPWR VGND sg13g2_decap_8
XFILLER_21_183 VPWR VGND sg13g2_decap_8
XFILLER_5_305 VPWR VGND sg13g2_decap_8
XFILLER_1_511 VPWR VGND sg13g2_decap_8
XFILLER_3_18 VPWR VGND sg13g2_decap_8
XFILLER_49_515 VPWR VGND sg13g2_decap_8
XFILLER_17_434 VPWR VGND sg13g2_decap_8
XFILLER_29_272 VPWR VGND sg13g2_decap_8
XFILLER_36_209 VPWR VGND sg13g2_decap_8
XFILLER_44_231 VPWR VGND sg13g2_decap_8
XFILLER_13_662 VPWR VGND sg13g2_fill_1
XFILLER_8_132 VPWR VGND sg13g2_decap_8
XFILLER_4_382 VPWR VGND sg13g2_decap_8
XFILLER_48_581 VPWR VGND sg13g2_decap_8
XFILLER_23_437 VPWR VGND sg13g2_decap_8
XFILLER_35_242 VPWR VGND sg13g2_decap_8
XFILLER_12_27 VPWR VGND sg13g2_decap_8
XFILLER_2_319 VPWR VGND sg13g2_decap_8
XFILLER_26_253 VPWR VGND sg13g2_decap_8
XFILLER_27_743 VPWR VGND sg13g2_fill_2
XFILLER_37_13 VPWR VGND sg13g2_fill_1
XFILLER_46_518 VPWR VGND sg13g2_decap_8
XFILLER_14_426 VPWR VGND sg13g2_decap_8
XFILLER_41_245 VPWR VGND sg13g2_decap_8
XFILLER_5_179 VPWR VGND sg13g2_decap_8
XFILLER_5_102 VPWR VGND sg13g2_decap_8
XFILLER_18_710 VPWR VGND sg13g2_decap_8
XFILLER_1_385 VPWR VGND sg13g2_decap_8
XFILLER_37_518 VPWR VGND sg13g2_decap_4
XFILLER_49_389 VPWR VGND sg13g2_decap_8
XFILLER_49_312 VPWR VGND sg13g2_decap_8
XFILLER_17_231 VPWR VGND sg13g2_decap_8
XFILLER_45_595 VPWR VGND sg13g2_decap_8
XFILLER_20_407 VPWR VGND sg13g2_decap_8
XFILLER_32_267 VPWR VGND sg13g2_decap_8
X_0893_ VPWR _0246_ daisychain\[53\] VGND sg13g2_inv_1
X_0962_ net98 VGND VPWR _0122_ daisychain\[58\] clknet_5_24__leaf_clk sg13g2_dfrbpq_1
XFILLER_9_452 VPWR VGND sg13g2_decap_8
XFILLER_28_529 VPWR VGND sg13g2_decap_8
XFILLER_23_15 VPWR VGND sg13g2_fill_1
XFILLER_23_234 VPWR VGND sg13g2_decap_8
XFILLER_2_116 VPWR VGND sg13g2_decap_8
XFILLER_19_518 VPWR VGND sg13g2_decap_8
XFILLER_46_315 VPWR VGND sg13g2_decap_8
XFILLER_48_56 VPWR VGND sg13g2_decap_8
XFILLER_14_223 VPWR VGND sg13g2_decap_8
XFILLER_15_757 VPWR VGND sg13g2_fill_1
XFILLER_15_768 VPWR VGND sg13g2_decap_8
XFILLER_27_595 VPWR VGND sg13g2_decap_8
XFILLER_42_532 VPWR VGND sg13g2_decap_8
XFILLER_10_440 VPWR VGND sg13g2_decap_8
XFILLER_23_790 VPWR VGND sg13g2_fill_1
Xfanout93 net94 net93 VPWR VGND sg13g2_buf_1
Xfanout82 net96 net82 VPWR VGND sg13g2_buf_1
Xfanout71 net72 net71 VPWR VGND sg13g2_buf_1
Xfanout60 net66 net60 VPWR VGND sg13g2_buf_1
XFILLER_9_39 VPWR VGND sg13g2_decap_8
XFILLER_6_411 VPWR VGND sg13g2_decap_8
XFILLER_6_488 VPWR VGND sg13g2_decap_8
XFILLER_18_540 VPWR VGND sg13g2_decap_8
XFILLER_1_182 VPWR VGND sg13g2_decap_8
XFILLER_49_186 VPWR VGND sg13g2_decap_8
XFILLER_20_204 VPWR VGND sg13g2_decap_8
XFILLER_33_510 VPWR VGND sg13g2_decap_8
XFILLER_33_587 VPWR VGND sg13g2_decap_8
XFILLER_45_392 VPWR VGND sg13g2_decap_8
X_0876_ VPWR _0004_ state\[45\] VGND sg13g2_inv_1
X_0945_ net114 VGND VPWR _0105_ daisychain\[41\] clknet_5_19__leaf_clk sg13g2_dfrbpq_1
XFILLER_24_543 VPWR VGND sg13g2_decap_8
XFILLER_28_326 VPWR VGND sg13g2_decap_8
XFILLER_36_370 VPWR VGND sg13g2_decap_8
XFILLER_43_329 VPWR VGND sg13g2_decap_8
XFILLER_44_808 VPWR VGND sg13g2_fill_1
XFILLER_44_819 VPWR VGND sg13g2_decap_4
XFILLER_34_47 VPWR VGND sg13g2_decap_8
XFILLER_3_403 VPWR VGND sg13g2_decap_8
XFILLER_19_315 VPWR VGND sg13g2_decap_8
XFILLER_46_112 VPWR VGND sg13g2_decap_8
XFILLER_47_602 VPWR VGND sg13g2_decap_8
XFILLER_47_679 VPWR VGND sg13g2_decap_8
XFILLER_15_510 VPWR VGND sg13g2_decap_8
XFILLER_15_587 VPWR VGND sg13g2_decap_8
XFILLER_27_392 VPWR VGND sg13g2_decap_8
XFILLER_46_189 VPWR VGND sg13g2_decap_8
XFILLER_30_557 VPWR VGND sg13g2_decap_8
X_0730_ _0289_ VPWR _0138_ VGND net83 _0033_ sg13g2_o21ai_1
X_0661_ VGND VPWR net28 daisychain\[48\] _0407_ net51 sg13g2_a21oi_1
XFILLER_7_742 VPWR VGND sg13g2_fill_2
XFILLER_6_285 VPWR VGND sg13g2_decap_8
XFILLER_2_480 VPWR VGND sg13g2_decap_8
XFILLER_34_4 VPWR VGND sg13g2_decap_4
X_0592_ _0225_ net69 _0354_ _0355_ VPWR VGND sg13g2_a21o_1
XFILLER_1_84 VPWR VGND sg13g2_decap_8
XFILLER_37_167 VPWR VGND sg13g2_decap_8
XFILLER_38_646 VPWR VGND sg13g2_decap_8
XFILLER_21_568 VPWR VGND sg13g2_decap_8
XFILLER_33_384 VPWR VGND sg13g2_decap_8
XFILLER_0_406 VPWR VGND sg13g2_decap_8
XFILLER_20_27 VPWR VGND sg13g2_fill_2
X_0859_ VPWR _0229_ daisychain\[36\] VGND sg13g2_inv_1
X_0928_ net103 VGND VPWR _0088_ daisychain\[24\] clknet_5_15__leaf_clk sg13g2_dfrbpq_1
XFILLER_28_123 VPWR VGND sg13g2_decap_8
XFILLER_29_69 VPWR VGND sg13g2_decap_8
XFILLER_24_351 VPWR VGND sg13g2_decap_8
XFILLER_43_126 VPWR VGND sg13g2_decap_8
XFILLER_44_616 VPWR VGND sg13g2_decap_8
XFILLER_45_35 VPWR VGND sg13g2_decap_8
XFILLER_12_557 VPWR VGND sg13g2_decap_8
XFILLER_3_200 VPWR VGND sg13g2_decap_8
XFILLER_8_517 VPWR VGND sg13g2_decap_8
XFILLER_6_29 VPWR VGND sg13g2_fill_1
XFILLER_6_18 VPWR VGND sg13g2_decap_8
XFILLER_3_277 VPWR VGND sg13g2_decap_8
XFILLER_19_112 VPWR VGND sg13g2_decap_8
XFILLER_19_189 VPWR VGND sg13g2_decap_8
XFILLER_19_91 VPWR VGND sg13g2_decap_8
XFILLER_47_476 VPWR VGND sg13g2_decap_8
XFILLER_15_384 VPWR VGND sg13g2_decap_8
XFILLER_30_354 VPWR VGND sg13g2_decap_8
XFILLER_34_159 VPWR VGND sg13g2_decap_8
X_0713_ VGND VPWR _0446_ _0445_ _0444_ sg13g2_or2_1
X_0644_ _0238_ net70 _0393_ _0394_ VPWR VGND sg13g2_a21o_1
XFILLER_7_583 VPWR VGND sg13g2_fill_1
XFILLER_38_454 VPWR VGND sg13g2_decap_8
X_0575_ net82 VPWR _0342_ VGND net60 state\[28\] sg13g2_o21ai_1
XFILLER_15_27 VPWR VGND sg13g2_decap_8
XFILLER_25_148 VPWR VGND sg13g2_decap_8
XFILLER_33_181 VPWR VGND sg13g2_decap_8
XFILLER_34_660 VPWR VGND sg13g2_fill_2
XFILLER_21_365 VPWR VGND sg13g2_decap_8
XFILLER_0_203 VPWR VGND sg13g2_decap_8
Xoutput15 net15 uo_out[0] VPWR VGND sg13g2_buf_1
XFILLER_16_148 VPWR VGND sg13g2_decap_8
XFILLER_17_616 VPWR VGND sg13g2_decap_8
XFILLER_29_454 VPWR VGND sg13g2_decap_8
XFILLER_44_413 VPWR VGND sg13g2_decap_8
XFILLER_12_321 VPWR VGND sg13g2_decap_8
XFILLER_13_811 VPWR VGND sg13g2_decap_8
XFILLER_40_685 VPWR VGND sg13g2_fill_1
XFILLER_8_314 VPWR VGND sg13g2_decap_8
XFILLER_21_92 VPWR VGND sg13g2_decap_8
XFILLER_0_770 VPWR VGND sg13g2_decap_8
XFILLER_48_763 VPWR VGND sg13g2_decap_8
XFILLER_22_118 VPWR VGND sg13g2_decap_8
XFILLER_23_619 VPWR VGND sg13g2_decap_8
XFILLER_35_424 VPWR VGND sg13g2_decap_8
XFILLER_47_273 VPWR VGND sg13g2_decap_8
XFILLER_15_181 VPWR VGND sg13g2_decap_8
XFILLER_30_151 VPWR VGND sg13g2_decap_8
XFILLER_43_490 VPWR VGND sg13g2_decap_8
X_0627_ net91 VPWR _0381_ VGND net69 state\[41\] sg13g2_o21ai_1
X_0558_ _0087_ _0328_ _0329_ net42 _0216_ VPWR VGND sg13g2_a22oi_1
XFILLER_26_15 VPWR VGND sg13g2_fill_2
XFILLER_26_435 VPWR VGND sg13g2_decap_8
XFILLER_38_251 VPWR VGND sg13g2_decap_8
X_0489_ VGND VPWR net23 daisychain\[5\] _0278_ net37 sg13g2_a21oi_1
XFILLER_13_129 VPWR VGND sg13g2_decap_8
XFILLER_14_608 VPWR VGND sg13g2_decap_4
XFILLER_21_162 VPWR VGND sg13g2_decap_8
XFILLER_22_685 VPWR VGND sg13g2_decap_8
XFILLER_41_427 VPWR VGND sg13g2_decap_8
XFILLER_42_14 VPWR VGND sg13g2_decap_8
XFILLER_17_413 VPWR VGND sg13g2_decap_8
XFILLER_29_251 VPWR VGND sg13g2_decap_8
XFILLER_44_210 VPWR VGND sg13g2_decap_8
XFILLER_44_287 VPWR VGND sg13g2_decap_8
XFILLER_12_195 VPWR VGND sg13g2_decap_8
XFILLER_13_674 VPWR VGND sg13g2_decap_8
XFILLER_13_685 VPWR VGND sg13g2_fill_1
XFILLER_16_92 VPWR VGND sg13g2_decap_8
XFILLER_32_449 VPWR VGND sg13g2_decap_8
XFILLER_8_188 VPWR VGND sg13g2_decap_8
XFILLER_8_111 VPWR VGND sg13g2_decap_8
XFILLER_4_361 VPWR VGND sg13g2_decap_8
XFILLER_35_221 VPWR VGND sg13g2_decap_8
XFILLER_48_560 VPWR VGND sg13g2_decap_8
XFILLER_23_416 VPWR VGND sg13g2_decap_8
XFILLER_35_298 VPWR VGND sg13g2_decap_8
XFILLER_14_405 VPWR VGND sg13g2_decap_8
XFILLER_26_232 VPWR VGND sg13g2_decap_8
XFILLER_27_733 VPWR VGND sg13g2_fill_1
XFILLER_37_36 VPWR VGND sg13g2_decap_4
XFILLER_37_69 VPWR VGND sg13g2_decap_8
XFILLER_41_224 VPWR VGND sg13g2_decap_8
XFILLER_22_482 VPWR VGND sg13g2_decap_8
XFILLER_2_821 VPWR VGND sg13g2_fill_2
XFILLER_5_158 VPWR VGND sg13g2_decap_8
XFILLER_17_210 VPWR VGND sg13g2_decap_8
XFILLER_1_364 VPWR VGND sg13g2_decap_8
XFILLER_49_368 VPWR VGND sg13g2_decap_8
XFILLER_17_287 VPWR VGND sg13g2_decap_8
XFILLER_27_91 VPWR VGND sg13g2_decap_8
XFILLER_32_246 VPWR VGND sg13g2_decap_8
XFILLER_45_574 VPWR VGND sg13g2_decap_8
X_0961_ net98 VGND VPWR _0121_ daisychain\[57\] clknet_5_24__leaf_clk sg13g2_dfrbpq_1
X_0892_ VPWR _0013_ state\[53\] VGND sg13g2_inv_1
XFILLER_9_431 VPWR VGND sg13g2_decap_8
XFILLER_4_95 VPWR VGND sg13g2_decap_8
XFILLER_23_213 VPWR VGND sg13g2_decap_8
XFILLER_28_508 VPWR VGND sg13g2_decap_8
Xclkbuf_5_18__f_clk clknet_5_18__leaf_clk clknet_4_9_0_clk VPWR VGND sg13g2_buf_16
XFILLER_48_35 VPWR VGND sg13g2_decap_8
XFILLER_14_202 VPWR VGND sg13g2_decap_8
XFILLER_14_279 VPWR VGND sg13g2_decap_8
XFILLER_27_574 VPWR VGND sg13g2_decap_8
XFILLER_42_511 VPWR VGND sg13g2_decap_8
XFILLER_42_588 VPWR VGND sg13g2_decap_8
XFILLER_9_18 VPWR VGND sg13g2_decap_8
XFILLER_10_496 VPWR VGND sg13g2_decap_8
Xfanout94 net95 net94 VPWR VGND sg13g2_buf_1
Xfanout83 net84 net83 VPWR VGND sg13g2_buf_1
Xfanout72 net73 net72 VPWR VGND sg13g2_buf_1
Xfanout61 net62 net61 VPWR VGND sg13g2_buf_1
Xfanout50 net52 net50 VPWR VGND sg13g2_buf_1
XFILLER_6_467 VPWR VGND sg13g2_decap_8
XFILLER_1_161 VPWR VGND sg13g2_decap_8
XFILLER_18_596 VPWR VGND sg13g2_decap_8
XFILLER_37_349 VPWR VGND sg13g2_decap_8
XFILLER_38_90 VPWR VGND sg13g2_decap_8
XFILLER_45_371 VPWR VGND sg13g2_decap_8
XFILLER_49_165 VPWR VGND sg13g2_decap_8
XFILLER_13_290 VPWR VGND sg13g2_decap_8
XFILLER_33_566 VPWR VGND sg13g2_decap_8
X_0944_ net109 VGND VPWR _0104_ daisychain\[40\] clknet_5_18__leaf_clk sg13g2_dfrbpq_1
X_0875_ VPWR _0237_ daisychain\[44\] VGND sg13g2_inv_1
XFILLER_28_305 VPWR VGND sg13g2_decap_8
XFILLER_24_522 VPWR VGND sg13g2_decap_8
XFILLER_43_308 VPWR VGND sg13g2_decap_8
XFILLER_11_249 VPWR VGND sg13g2_decap_8
XFILLER_24_599 VPWR VGND sg13g2_decap_8
XFILLER_3_459 VPWR VGND sg13g2_decap_8
XFILLER_27_371 VPWR VGND sg13g2_decap_8
XFILLER_46_168 VPWR VGND sg13g2_decap_8
XFILLER_47_658 VPWR VGND sg13g2_decap_8
XFILLER_15_566 VPWR VGND sg13g2_decap_8
XFILLER_24_92 VPWR VGND sg13g2_decap_8
XFILLER_30_536 VPWR VGND sg13g2_decap_8
XFILLER_42_385 VPWR VGND sg13g2_decap_8
XFILLER_10_293 VPWR VGND sg13g2_decap_8
XFILLER_40_91 VPWR VGND sg13g2_decap_8
X_0660_ _0242_ net72 _0405_ _0406_ VPWR VGND sg13g2_a21o_1
X_0591_ net91 VPWR _0354_ VGND net69 state\[32\] sg13g2_o21ai_1
XFILLER_7_732 VPWR VGND sg13g2_fill_2
XFILLER_6_264 VPWR VGND sg13g2_decap_8
XFILLER_18_393 VPWR VGND sg13g2_decap_8
XFILLER_1_63 VPWR VGND sg13g2_decap_8
XFILLER_33_363 VPWR VGND sg13g2_decap_8
XFILLER_37_146 VPWR VGND sg13g2_decap_8
XFILLER_21_547 VPWR VGND sg13g2_decap_8
X_0927_ net104 VGND VPWR _0087_ daisychain\[23\] clknet_5_4__leaf_clk sg13g2_dfrbpq_1
X_0858_ VPWR _0026_ state\[36\] VGND sg13g2_inv_1
X_0789_ VPWR _0194_ daisychain\[1\] VGND sg13g2_inv_1
XFILLER_28_102 VPWR VGND sg13g2_decap_8
XFILLER_28_179 VPWR VGND sg13g2_decap_8
XFILLER_29_48 VPWR VGND sg13g2_decap_8
XFILLER_29_636 VPWR VGND sg13g2_decap_8
XFILLER_43_105 VPWR VGND sg13g2_decap_8
XFILLER_45_14 VPWR VGND sg13g2_decap_8
XFILLER_12_536 VPWR VGND sg13g2_decap_8
XFILLER_24_330 VPWR VGND sg13g2_decap_8
XFILLER_10_83 VPWR VGND sg13g2_decap_8
XFILLER_3_256 VPWR VGND sg13g2_decap_8
XFILLER_15_363 VPWR VGND sg13g2_decap_8
XFILLER_19_168 VPWR VGND sg13g2_decap_8
XFILLER_19_70 VPWR VGND sg13g2_decap_8
XFILLER_34_138 VPWR VGND sg13g2_decap_8
XFILLER_35_606 VPWR VGND sg13g2_fill_2
XFILLER_47_455 VPWR VGND sg13g2_decap_8
XFILLER_11_591 VPWR VGND sg13g2_decap_4
XFILLER_30_333 VPWR VGND sg13g2_decap_8
XFILLER_42_182 VPWR VGND sg13g2_decap_8
X_0712_ net76 VPWR _0445_ VGND net55 state\[62\] sg13g2_o21ai_1
X_0643_ net92 VPWR _0393_ VGND net70 state\[45\] sg13g2_o21ai_1
X_0574_ _0091_ _0340_ _0341_ net38 _0220_ VPWR VGND sg13g2_a22oi_1
XFILLER_26_617 VPWR VGND sg13g2_decap_8
XFILLER_38_433 VPWR VGND sg13g2_decap_8
XFILLER_18_190 VPWR VGND sg13g2_decap_8
XFILLER_21_344 VPWR VGND sg13g2_decap_8
XFILLER_25_127 VPWR VGND sg13g2_decap_8
XFILLER_33_160 VPWR VGND sg13g2_decap_8
XFILLER_40_119 VPWR VGND sg13g2_decap_8
XFILLER_41_609 VPWR VGND sg13g2_decap_8
XFILLER_0_259 VPWR VGND sg13g2_decap_8
Xoutput16 net16 uo_out[1] VPWR VGND sg13g2_buf_1
XFILLER_16_127 VPWR VGND sg13g2_decap_8
XFILLER_29_433 VPWR VGND sg13g2_decap_8
XFILLER_44_469 VPWR VGND sg13g2_decap_8
XFILLER_12_300 VPWR VGND sg13g2_decap_8
XFILLER_12_377 VPWR VGND sg13g2_fill_1
XFILLER_21_71 VPWR VGND sg13g2_decap_8
XFILLER_35_403 VPWR VGND sg13g2_decap_8
XFILLER_47_252 VPWR VGND sg13g2_decap_8
XFILLER_48_742 VPWR VGND sg13g2_decap_8
XFILLER_15_160 VPWR VGND sg13g2_decap_8
XFILLER_30_130 VPWR VGND sg13g2_decap_8
XFILLER_31_620 VPWR VGND sg13g2_decap_8
Xclkbuf_0_clk clknet_0_clk clk VPWR VGND sg13g2_buf_16
XFILLER_7_84 VPWR VGND sg13g2_decap_8
XFILLER_7_392 VPWR VGND sg13g2_decap_8
X_0626_ _0104_ _0379_ _0380_ net49 _0233_ VPWR VGND sg13g2_a22oi_1
X_0557_ VGND VPWR net25 daisychain\[22\] _0329_ net42 sg13g2_a21oi_1
XFILLER_26_414 VPWR VGND sg13g2_decap_8
XFILLER_38_230 VPWR VGND sg13g2_decap_8
XFILLER_41_406 VPWR VGND sg13g2_decap_8
X_0488_ _0199_ net59 _0276_ _0277_ VPWR VGND sg13g2_a21o_1
XFILLER_13_108 VPWR VGND sg13g2_decap_8
XFILLER_21_141 VPWR VGND sg13g2_decap_8
XFILLER_22_664 VPWR VGND sg13g2_decap_8
XFILLER_1_546 VPWR VGND sg13g2_decap_8
XFILLER_29_230 VPWR VGND sg13g2_decap_8
XFILLER_16_71 VPWR VGND sg13g2_decap_8
XFILLER_17_469 VPWR VGND sg13g2_decap_8
XFILLER_25_491 VPWR VGND sg13g2_decap_8
XFILLER_32_428 VPWR VGND sg13g2_decap_8
XFILLER_44_266 VPWR VGND sg13g2_decap_8
XFILLER_12_174 VPWR VGND sg13g2_decap_8
XFILLER_32_92 VPWR VGND sg13g2_decap_8
XFILLER_40_483 VPWR VGND sg13g2_decap_8
XFILLER_9_635 VPWR VGND sg13g2_decap_8
XFILLER_8_167 VPWR VGND sg13g2_decap_8
XFILLER_4_340 VPWR VGND sg13g2_decap_8
XFILLER_35_200 VPWR VGND sg13g2_decap_8
XFILLER_16_491 VPWR VGND sg13g2_decap_8
XFILLER_31_494 VPWR VGND sg13g2_decap_8
XFILLER_35_277 VPWR VGND sg13g2_decap_8
XFILLER_8_690 VPWR VGND sg13g2_fill_2
X_0609_ VGND VPWR net29 daisychain\[35\] _0368_ net46 sg13g2_a21oi_1
XFILLER_26_211 VPWR VGND sg13g2_decap_8
XFILLER_26_288 VPWR VGND sg13g2_decap_8
XFILLER_27_745 VPWR VGND sg13g2_fill_1
XFILLER_39_583 VPWR VGND sg13g2_decap_8
XFILLER_41_203 VPWR VGND sg13g2_decap_8
XFILLER_22_461 VPWR VGND sg13g2_decap_8
XFILLER_5_137 VPWR VGND sg13g2_decap_8
XFILLER_1_343 VPWR VGND sg13g2_decap_8
XFILLER_18_778 VPWR VGND sg13g2_decap_8
XFILLER_27_70 VPWR VGND sg13g2_decap_8
XFILLER_45_553 VPWR VGND sg13g2_decap_8
XFILLER_49_347 VPWR VGND sg13g2_decap_8
XFILLER_13_483 VPWR VGND sg13g2_decap_8
XFILLER_17_266 VPWR VGND sg13g2_decap_8
XFILLER_32_225 VPWR VGND sg13g2_decap_8
XFILLER_40_280 VPWR VGND sg13g2_decap_8
XFILLER_43_91 VPWR VGND sg13g2_decap_8
X_0960_ net110 VGND VPWR _0120_ daisychain\[56\] clknet_5_25__leaf_clk sg13g2_dfrbpq_1
XFILLER_9_410 VPWR VGND sg13g2_decap_8
X_0891_ VPWR _0245_ daisychain\[52\] VGND sg13g2_inv_1
XFILLER_9_487 VPWR VGND sg13g2_decap_8
XFILLER_4_74 VPWR VGND sg13g2_decap_8
XFILLER_24_737 VPWR VGND sg13g2_decap_8
XFILLER_36_531 VPWR VGND sg13g2_decap_4
XFILLER_36_597 VPWR VGND sg13g2_decap_8
XFILLER_23_269 VPWR VGND sg13g2_decap_8
XFILLER_31_291 VPWR VGND sg13g2_decap_8
XFILLER_48_14 VPWR VGND sg13g2_decap_8
XFILLER_27_553 VPWR VGND sg13g2_decap_8
XFILLER_47_807 VPWR VGND sg13g2_decap_8
XFILLER_14_258 VPWR VGND sg13g2_decap_8
XFILLER_42_567 VPWR VGND sg13g2_decap_8
Xfanout73 net74 net73 VPWR VGND sg13g2_buf_1
Xfanout62 net65 net62 VPWR VGND sg13g2_buf_1
Xfanout51 net52 net51 VPWR VGND sg13g2_buf_1
Xfanout40 net43 net40 VPWR VGND sg13g2_buf_1
XFILLER_10_475 VPWR VGND sg13g2_decap_8
XFILLER_13_94 VPWR VGND sg13g2_decap_8
Xfanout95 net96 net95 VPWR VGND sg13g2_buf_1
Xfanout84 net87 net84 VPWR VGND sg13g2_buf_1
XFILLER_6_446 VPWR VGND sg13g2_decap_8
XFILLER_1_140 VPWR VGND sg13g2_decap_8
XFILLER_29_8 VPWR VGND sg13g2_fill_1
XFILLER_2_685 VPWR VGND sg13g2_fill_2
XFILLER_49_144 VPWR VGND sg13g2_decap_8
XFILLER_18_575 VPWR VGND sg13g2_decap_8
XFILLER_33_545 VPWR VGND sg13g2_decap_8
XFILLER_37_328 VPWR VGND sg13g2_decap_8
XFILLER_45_350 VPWR VGND sg13g2_decap_8
Xclkbuf_5_24__f_clk clknet_5_24__leaf_clk clknet_4_12_0_clk VPWR VGND sg13g2_buf_16
XFILLER_20_239 VPWR VGND sg13g2_decap_8
XFILLER_21_729 VPWR VGND sg13g2_decap_8
X_0874_ VPWR _0003_ state\[44\] VGND sg13g2_inv_1
X_0943_ net110 VGND VPWR _0103_ daisychain\[39\] clknet_5_27__leaf_clk sg13g2_dfrbpq_1
XFILLER_9_284 VPWR VGND sg13g2_decap_8
XFILLER_48_0 VPWR VGND sg13g2_decap_8
XFILLER_11_228 VPWR VGND sg13g2_decap_8
XFILLER_24_501 VPWR VGND sg13g2_decap_8
XFILLER_24_578 VPWR VGND sg13g2_decap_8
XFILLER_3_438 VPWR VGND sg13g2_decap_8
XFILLER_15_545 VPWR VGND sg13g2_decap_8
XFILLER_27_350 VPWR VGND sg13g2_decap_8
XFILLER_46_147 VPWR VGND sg13g2_decap_8
XFILLER_47_637 VPWR VGND sg13g2_decap_8
XFILLER_24_71 VPWR VGND sg13g2_decap_8
XFILLER_30_515 VPWR VGND sg13g2_decap_8
XFILLER_42_364 VPWR VGND sg13g2_decap_8
XFILLER_10_272 VPWR VGND sg13g2_decap_8
XFILLER_40_70 VPWR VGND sg13g2_decap_8
XFILLER_41_7 VPWR VGND sg13g2_decap_8
X_0590_ _0095_ _0352_ _0353_ net42 _0224_ VPWR VGND sg13g2_a22oi_1
XFILLER_6_243 VPWR VGND sg13g2_decap_8
XFILLER_1_42 VPWR VGND sg13g2_decap_8
XFILLER_37_125 VPWR VGND sg13g2_decap_8
XFILLER_18_372 VPWR VGND sg13g2_decap_8
XFILLER_21_526 VPWR VGND sg13g2_decap_8
XFILLER_25_309 VPWR VGND sg13g2_decap_8
XFILLER_33_342 VPWR VGND sg13g2_decap_8
X_0857_ VPWR _0228_ daisychain\[35\] VGND sg13g2_inv_1
X_0926_ net107 VGND VPWR _0086_ daisychain\[22\] clknet_5_6__leaf_clk sg13g2_dfrbpq_1
XFILLER_29_27 VPWR VGND sg13g2_decap_8
X_0788_ VPWR _0043_ state\[1\] VGND sg13g2_inv_1
XFILLER_16_309 VPWR VGND sg13g2_decap_8
XFILLER_25_821 VPWR VGND sg13g2_fill_2
XFILLER_28_158 VPWR VGND sg13g2_decap_8
XFILLER_29_615 VPWR VGND sg13g2_decap_8
XFILLER_12_515 VPWR VGND sg13g2_decap_8
XFILLER_24_386 VPWR VGND sg13g2_decap_8
XFILLER_10_62 VPWR VGND sg13g2_decap_8
XFILLER_3_235 VPWR VGND sg13g2_decap_8
XFILLER_19_147 VPWR VGND sg13g2_decap_8
XFILLER_47_434 VPWR VGND sg13g2_decap_8
XFILLER_15_342 VPWR VGND sg13g2_decap_8
XFILLER_16_821 VPWR VGND sg13g2_fill_2
XFILLER_30_312 VPWR VGND sg13g2_decap_8
XFILLER_34_117 VPWR VGND sg13g2_decap_8
XFILLER_35_81 VPWR VGND sg13g2_decap_8
XFILLER_42_161 VPWR VGND sg13g2_decap_8
XFILLER_43_651 VPWR VGND sg13g2_decap_4
XFILLER_11_570 VPWR VGND sg13g2_decap_8
XFILLER_30_389 VPWR VGND sg13g2_decap_8
X_0711_ daisychain\[62\] net55 _0444_ VPWR VGND sg13g2_nor2b_1
X_0642_ _0108_ _0391_ _0392_ net48 _0237_ VPWR VGND sg13g2_a22oi_1
X_0573_ VGND VPWR net24 daisychain\[26\] _0341_ net38 sg13g2_a21oi_1
XFILLER_19_681 VPWR VGND sg13g2_fill_1
XFILLER_25_106 VPWR VGND sg13g2_decap_8
XFILLER_38_412 VPWR VGND sg13g2_decap_8
XFILLER_21_323 VPWR VGND sg13g2_decap_8
XFILLER_31_39 VPWR VGND sg13g2_decap_8
X_0909_ net101 VGND VPWR _0069_ daisychain\[5\] clknet_5_12__leaf_clk sg13g2_dfrbpq_1
Xoutput17 net17 uo_out[2] VPWR VGND sg13g2_buf_1
XFILLER_0_238 VPWR VGND sg13g2_decap_8
XFILLER_29_412 VPWR VGND sg13g2_decap_8
XFILLER_16_106 VPWR VGND sg13g2_decap_8
XFILLER_25_662 VPWR VGND sg13g2_decap_8
XFILLER_29_489 VPWR VGND sg13g2_decap_8
XFILLER_31_109 VPWR VGND sg13g2_decap_8
XFILLER_40_610 VPWR VGND sg13g2_decap_8
XFILLER_40_621 VPWR VGND sg13g2_fill_1
XFILLER_44_448 VPWR VGND sg13g2_decap_8
XFILLER_12_356 VPWR VGND sg13g2_decap_8
XFILLER_24_183 VPWR VGND sg13g2_decap_8
XFILLER_8_349 VPWR VGND sg13g2_decap_8
XFILLER_21_50 VPWR VGND sg13g2_decap_8
XFILLER_4_522 VPWR VGND sg13g2_decap_8
XFILLER_47_231 VPWR VGND sg13g2_decap_8
XFILLER_48_798 VPWR VGND sg13g2_decap_8
XFILLER_48_721 VPWR VGND sg13g2_decap_8
XFILLER_35_459 VPWR VGND sg13g2_decap_8
XFILLER_46_91 VPWR VGND sg13g2_decap_8
XFILLER_30_186 VPWR VGND sg13g2_decap_8
X_0625_ VGND VPWR net28 daisychain\[39\] _0380_ net46 sg13g2_a21oi_1
XFILLER_7_63 VPWR VGND sg13g2_decap_8
XFILLER_7_371 VPWR VGND sg13g2_decap_8
X_0556_ _0216_ net64 _0327_ _0328_ VPWR VGND sg13g2_a21o_1
X_0487_ net80 VPWR _0276_ VGND net58 state\[6\] sg13g2_o21ai_1
XFILLER_38_286 VPWR VGND sg13g2_decap_8
XFILLER_21_120 VPWR VGND sg13g2_decap_8
XFILLER_21_197 VPWR VGND sg13g2_decap_8
XFILLER_22_643 VPWR VGND sg13g2_decap_8
XFILLER_34_481 VPWR VGND sg13g2_decap_8
XFILLER_42_49 VPWR VGND sg13g2_decap_8
XFILLER_5_319 VPWR VGND sg13g2_decap_8
XFILLER_1_525 VPWR VGND sg13g2_decap_8
XFILLER_29_286 VPWR VGND sg13g2_decap_8
XFILLER_45_702 VPWR VGND sg13g2_decap_8
Xclkbuf_5_5__f_clk clknet_5_5__leaf_clk clknet_4_2_0_clk VPWR VGND sg13g2_buf_16
XFILLER_49_529 VPWR VGND sg13g2_decap_8
XFILLER_12_153 VPWR VGND sg13g2_decap_8
XFILLER_16_50 VPWR VGND sg13g2_decap_8
XFILLER_17_448 VPWR VGND sg13g2_decap_8
XFILLER_25_470 VPWR VGND sg13g2_decap_8
XFILLER_32_407 VPWR VGND sg13g2_decap_8
XFILLER_40_462 VPWR VGND sg13g2_decap_8
XFILLER_44_245 VPWR VGND sg13g2_decap_8
XFILLER_32_71 VPWR VGND sg13g2_decap_8
XFILLER_8_146 VPWR VGND sg13g2_decap_8
XFILLER_4_396 VPWR VGND sg13g2_decap_8
XFILLER_35_256 VPWR VGND sg13g2_decap_8
XFILLER_36_713 VPWR VGND sg13g2_fill_2
XFILLER_48_595 VPWR VGND sg13g2_decap_8
XFILLER_16_470 VPWR VGND sg13g2_decap_8
XFILLER_31_473 VPWR VGND sg13g2_decap_8
X_0608_ _0229_ net67 _0366_ _0367_ VPWR VGND sg13g2_a21o_1
XFILLER_39_562 VPWR VGND sg13g2_decap_8
X_0539_ net85 VPWR _0315_ VGND net63 state\[19\] sg13g2_o21ai_1
XFILLER_22_440 VPWR VGND sg13g2_decap_8
XFILLER_26_267 VPWR VGND sg13g2_decap_8
XFILLER_41_259 VPWR VGND sg13g2_decap_8
XFILLER_5_116 VPWR VGND sg13g2_decap_8
XFILLER_1_322 VPWR VGND sg13g2_decap_8
XFILLER_1_399 VPWR VGND sg13g2_decap_8
XFILLER_49_326 VPWR VGND sg13g2_decap_8
XFILLER_17_245 VPWR VGND sg13g2_decap_8
XFILLER_18_724 VPWR VGND sg13g2_decap_8
XFILLER_32_204 VPWR VGND sg13g2_decap_8
XFILLER_45_532 VPWR VGND sg13g2_decap_8
XFILLER_13_462 VPWR VGND sg13g2_decap_8
XFILLER_43_70 VPWR VGND sg13g2_decap_8
X_0890_ VPWR _0012_ state\[52\] VGND sg13g2_inv_1
XFILLER_9_466 VPWR VGND sg13g2_decap_8
XFILLER_4_193 VPWR VGND sg13g2_decap_8
XFILLER_36_510 VPWR VGND sg13g2_decap_8
XFILLER_4_53 VPWR VGND sg13g2_decap_8
XFILLER_23_248 VPWR VGND sg13g2_decap_8
XFILLER_36_576 VPWR VGND sg13g2_decap_8
XFILLER_48_392 VPWR VGND sg13g2_decap_8
XFILLER_31_270 VPWR VGND sg13g2_decap_8
XFILLER_27_532 VPWR VGND sg13g2_decap_8
XFILLER_39_392 VPWR VGND sg13g2_decap_8
XFILLER_46_329 VPWR VGND sg13g2_decap_8
XFILLER_14_237 VPWR VGND sg13g2_decap_8
XFILLER_42_546 VPWR VGND sg13g2_decap_8
Xfanout30 net31 net30 VPWR VGND sg13g2_buf_1
Xfanout96 net97 net96 VPWR VGND sg13g2_buf_1
Xfanout85 net87 net85 VPWR VGND sg13g2_buf_1
Xfanout74 net75 net74 VPWR VGND sg13g2_buf_1
Xfanout63 net65 net63 VPWR VGND sg13g2_buf_1
Xfanout52 net53 net52 VPWR VGND sg13g2_buf_1
Xfanout41 net43 net41 VPWR VGND sg13g2_buf_1
XFILLER_10_454 VPWR VGND sg13g2_decap_8
XFILLER_13_73 VPWR VGND sg13g2_decap_8
XFILLER_6_425 VPWR VGND sg13g2_decap_8
XFILLER_1_196 VPWR VGND sg13g2_decap_8
XFILLER_37_307 VPWR VGND sg13g2_decap_8
XFILLER_49_123 VPWR VGND sg13g2_decap_8
XFILLER_18_554 VPWR VGND sg13g2_decap_8
XFILLER_33_524 VPWR VGND sg13g2_decap_8
XFILLER_14_793 VPWR VGND sg13g2_fill_1
XFILLER_20_218 VPWR VGND sg13g2_decap_8
X_0873_ VPWR _0236_ daisychain\[43\] VGND sg13g2_inv_1
X_0942_ net110 VGND VPWR _0102_ daisychain\[38\] clknet_5_29__leaf_clk sg13g2_dfrbpq_1
XFILLER_9_263 VPWR VGND sg13g2_decap_8
XFILLER_5_480 VPWR VGND sg13g2_decap_8
XFILLER_49_690 VPWR VGND sg13g2_decap_8
XFILLER_11_207 VPWR VGND sg13g2_decap_8
XFILLER_24_557 VPWR VGND sg13g2_decap_8
XFILLER_36_384 VPWR VGND sg13g2_decap_8
XFILLER_3_417 VPWR VGND sg13g2_decap_8
Xclkbuf_5_30__f_clk clknet_5_30__leaf_clk clknet_4_15_0_clk VPWR VGND sg13g2_buf_16
XFILLER_19_329 VPWR VGND sg13g2_decap_8
XFILLER_1_7 VPWR VGND sg13g2_decap_8
XFILLER_47_616 VPWR VGND sg13g2_decap_8
XFILLER_15_524 VPWR VGND sg13g2_decap_8
XFILLER_42_343 VPWR VGND sg13g2_decap_8
XFILLER_46_126 VPWR VGND sg13g2_decap_8
XFILLER_10_251 VPWR VGND sg13g2_decap_8
XFILLER_11_730 VPWR VGND sg13g2_fill_1
XFILLER_24_50 VPWR VGND sg13g2_decap_8
XFILLER_6_222 VPWR VGND sg13g2_decap_8
XFILLER_6_299 VPWR VGND sg13g2_decap_8
XFILLER_18_351 VPWR VGND sg13g2_decap_8
XFILLER_1_21 VPWR VGND sg13g2_decap_8
XFILLER_1_98 VPWR VGND sg13g2_decap_8
XFILLER_2_494 VPWR VGND sg13g2_decap_8
XFILLER_37_104 VPWR VGND sg13g2_decap_8
XFILLER_21_505 VPWR VGND sg13g2_decap_8
XFILLER_33_321 VPWR VGND sg13g2_decap_8
XFILLER_33_398 VPWR VGND sg13g2_decap_8
XFILLER_46_693 VPWR VGND sg13g2_decap_8
X_0856_ VPWR _0025_ state\[35\] VGND sg13g2_inv_1
X_0925_ net107 VGND VPWR _0085_ daisychain\[21\] clknet_5_7__leaf_clk sg13g2_dfrbpq_1
X_0787_ VPWR _0193_ daisychain\[0\] VGND sg13g2_inv_1
XFILLER_28_137 VPWR VGND sg13g2_decap_8
XFILLER_36_181 VPWR VGND sg13g2_decap_8
XFILLER_37_693 VPWR VGND sg13g2_decap_4
XFILLER_45_49 VPWR VGND sg13g2_decap_8
XFILLER_20_582 VPWR VGND sg13g2_decap_8
XFILLER_24_365 VPWR VGND sg13g2_decap_8
XFILLER_10_41 VPWR VGND sg13g2_decap_8
XFILLER_3_214 VPWR VGND sg13g2_decap_8
XFILLER_19_126 VPWR VGND sg13g2_decap_8
XFILLER_47_413 VPWR VGND sg13g2_decap_8
XFILLER_15_321 VPWR VGND sg13g2_decap_8
XFILLER_15_398 VPWR VGND sg13g2_decap_8
XFILLER_35_60 VPWR VGND sg13g2_decap_8
XFILLER_42_140 VPWR VGND sg13g2_decap_8
XFILLER_43_630 VPWR VGND sg13g2_decap_8
XFILLER_30_368 VPWR VGND sg13g2_decap_8
X_0710_ _0125_ _0442_ _0443_ net33 _0254_ VPWR VGND sg13g2_a22oi_1
X_0641_ VGND VPWR net27 daisychain\[43\] _0392_ net48 sg13g2_a21oi_1
XFILLER_2_291 VPWR VGND sg13g2_decap_8
XFILLER_32_4 VPWR VGND sg13g2_decap_8
X_0572_ _0220_ net60 _0339_ _0340_ VPWR VGND sg13g2_a21o_1
XFILLER_38_468 VPWR VGND sg13g2_decap_8
XFILLER_46_490 VPWR VGND sg13g2_decap_8
X_1055_ daisychain\[63\] net22 VPWR VGND sg13g2_buf_1
XFILLER_21_302 VPWR VGND sg13g2_decap_8
XFILLER_21_379 VPWR VGND sg13g2_decap_8
XFILLER_31_18 VPWR VGND sg13g2_decap_8
XFILLER_33_195 VPWR VGND sg13g2_decap_8
XFILLER_0_217 VPWR VGND sg13g2_decap_8
X_0908_ net99 VGND VPWR _0068_ daisychain\[4\] clknet_5_12__leaf_clk sg13g2_dfrbpq_1
Xoutput18 net18 uo_out[3] VPWR VGND sg13g2_buf_1
X_0839_ VPWR _0219_ daisychain\[26\] VGND sg13g2_inv_1
XFILLER_29_468 VPWR VGND sg13g2_decap_8
XFILLER_12_335 VPWR VGND sg13g2_decap_8
XFILLER_24_162 VPWR VGND sg13g2_decap_8
XFILLER_37_490 VPWR VGND sg13g2_decap_8
XFILLER_44_427 VPWR VGND sg13g2_decap_8
XFILLER_8_328 VPWR VGND sg13g2_decap_8
XFILLER_4_501 VPWR VGND sg13g2_decap_8
XFILLER_0_740 VPWR VGND sg13g2_fill_2
XFILLER_0_762 VPWR VGND sg13g2_decap_4
XFILLER_48_700 VPWR VGND sg13g2_decap_8
XFILLER_0_784 VPWR VGND sg13g2_decap_8
XFILLER_16_641 VPWR VGND sg13g2_fill_2
XFILLER_35_438 VPWR VGND sg13g2_decap_8
XFILLER_46_70 VPWR VGND sg13g2_decap_8
XFILLER_47_210 VPWR VGND sg13g2_decap_8
XFILLER_47_287 VPWR VGND sg13g2_decap_8
XFILLER_48_777 VPWR VGND sg13g2_decap_8
XFILLER_15_195 VPWR VGND sg13g2_decap_8
XFILLER_16_685 VPWR VGND sg13g2_fill_1
XFILLER_30_165 VPWR VGND sg13g2_decap_8
X_0624_ _0233_ net68 _0378_ _0379_ VPWR VGND sg13g2_a21o_1
XFILLER_7_42 VPWR VGND sg13g2_decap_8
XFILLER_7_350 VPWR VGND sg13g2_decap_8
XFILLER_39_711 VPWR VGND sg13g2_fill_1
X_0555_ net83 VPWR _0327_ VGND net62 state\[23\] sg13g2_o21ai_1
X_0486_ _0069_ _0274_ _0275_ net37 _0198_ VPWR VGND sg13g2_a22oi_1
XFILLER_19_490 VPWR VGND sg13g2_decap_8
XFILLER_22_622 VPWR VGND sg13g2_decap_8
XFILLER_26_29 VPWR VGND sg13g2_decap_8
XFILLER_26_449 VPWR VGND sg13g2_decap_8
XFILLER_34_460 VPWR VGND sg13g2_decap_8
XFILLER_38_265 VPWR VGND sg13g2_decap_8
XFILLER_21_176 VPWR VGND sg13g2_decap_8
XFILLER_42_28 VPWR VGND sg13g2_decap_8
XFILLER_1_504 VPWR VGND sg13g2_decap_8
XFILLER_49_508 VPWR VGND sg13g2_decap_8
XFILLER_17_427 VPWR VGND sg13g2_decap_8
XFILLER_29_265 VPWR VGND sg13g2_decap_8
XFILLER_44_224 VPWR VGND sg13g2_decap_8
XFILLER_12_132 VPWR VGND sg13g2_decap_8
XFILLER_40_441 VPWR VGND sg13g2_decap_8
XFILLER_8_125 VPWR VGND sg13g2_decap_8
XFILLER_32_50 VPWR VGND sg13g2_decap_8
XFILLER_4_375 VPWR VGND sg13g2_decap_8
XFILLER_0_581 VPWR VGND sg13g2_decap_8
XFILLER_0_592 VPWR VGND sg13g2_fill_1
XFILLER_35_235 VPWR VGND sg13g2_decap_8
XFILLER_48_574 VPWR VGND sg13g2_decap_8
XFILLER_31_452 VPWR VGND sg13g2_decap_8
X_0607_ net88 VPWR _0366_ VGND net67 state\[36\] sg13g2_o21ai_1
X_0538_ _0082_ _0313_ _0314_ net40 _0211_ VPWR VGND sg13g2_a22oi_1
XFILLER_26_246 VPWR VGND sg13g2_decap_8
XFILLER_39_541 VPWR VGND sg13g2_decap_8
X_0469_ VGND VPWR net31 daisychain\[0\] _0263_ net35 sg13g2_a21oi_1
XFILLER_14_419 VPWR VGND sg13g2_decap_8
XFILLER_41_238 VPWR VGND sg13g2_decap_8
XFILLER_1_301 VPWR VGND sg13g2_decap_8
XFILLER_22_496 VPWR VGND sg13g2_decap_8
XFILLER_1_378 VPWR VGND sg13g2_decap_8
XFILLER_49_305 VPWR VGND sg13g2_decap_8
XFILLER_17_224 VPWR VGND sg13g2_decap_8
XFILLER_45_511 VPWR VGND sg13g2_decap_8
XFILLER_45_588 VPWR VGND sg13g2_decap_8
XFILLER_13_441 VPWR VGND sg13g2_decap_8
XFILLER_9_445 VPWR VGND sg13g2_decap_8
XFILLER_4_32 VPWR VGND sg13g2_decap_8
XFILLER_4_172 VPWR VGND sg13g2_decap_8
XFILLER_48_371 VPWR VGND sg13g2_decap_8
XFILLER_23_227 VPWR VGND sg13g2_decap_8
XFILLER_2_109 VPWR VGND sg13g2_decap_8
XFILLER_48_49 VPWR VGND sg13g2_decap_8
XFILLER_14_216 VPWR VGND sg13g2_decap_8
XFILLER_27_511 VPWR VGND sg13g2_decap_8
XFILLER_27_588 VPWR VGND sg13g2_decap_8
XFILLER_39_371 VPWR VGND sg13g2_decap_8
XFILLER_42_525 VPWR VGND sg13g2_decap_8
XFILLER_46_308 VPWR VGND sg13g2_decap_8
XFILLER_10_433 VPWR VGND sg13g2_decap_8
XFILLER_13_52 VPWR VGND sg13g2_decap_8
XFILLER_22_293 VPWR VGND sg13g2_decap_8
XFILLER_23_761 VPWR VGND sg13g2_decap_4
XFILLER_23_783 VPWR VGND sg13g2_decap_8
Xfanout31 _0192_ net31 VPWR VGND sg13g2_buf_1
Xfanout97 net4 net97 VPWR VGND sg13g2_buf_1
Xfanout86 net87 net86 VPWR VGND sg13g2_buf_1
Xfanout75 net5 net75 VPWR VGND sg13g2_buf_1
Xfanout64 net65 net64 VPWR VGND sg13g2_buf_1
Xfanout53 net54 net53 VPWR VGND sg13g2_buf_1
Xfanout42 net43 net42 VPWR VGND sg13g2_buf_1
XFILLER_6_404 VPWR VGND sg13g2_decap_8
XFILLER_2_643 VPWR VGND sg13g2_decap_4
XFILLER_18_533 VPWR VGND sg13g2_decap_8
XFILLER_1_175 VPWR VGND sg13g2_decap_8
XFILLER_2_687 VPWR VGND sg13g2_fill_1
XFILLER_49_179 VPWR VGND sg13g2_decap_8
XFILLER_49_102 VPWR VGND sg13g2_decap_8
XFILLER_33_503 VPWR VGND sg13g2_decap_8
XFILLER_45_385 VPWR VGND sg13g2_decap_8
X_0941_ net110 VGND VPWR _0101_ daisychain\[37\] clknet_5_26__leaf_clk sg13g2_dfrbpq_1
X_0872_ VPWR _0002_ state\[43\] VGND sg13g2_inv_1
XFILLER_9_242 VPWR VGND sg13g2_decap_8
XFILLER_24_536 VPWR VGND sg13g2_decap_8
XFILLER_28_319 VPWR VGND sg13g2_decap_8
XFILLER_36_363 VPWR VGND sg13g2_decap_8
XFILLER_19_308 VPWR VGND sg13g2_decap_8
XFILLER_46_105 VPWR VGND sg13g2_decap_8
XFILLER_15_503 VPWR VGND sg13g2_decap_8
XFILLER_27_385 VPWR VGND sg13g2_decap_8
XFILLER_42_322 VPWR VGND sg13g2_decap_8
XFILLER_10_230 VPWR VGND sg13g2_decap_8
XFILLER_23_591 VPWR VGND sg13g2_decap_8
XFILLER_42_399 VPWR VGND sg13g2_decap_8
XFILLER_6_278 VPWR VGND sg13g2_decap_8
XFILLER_6_201 VPWR VGND sg13g2_decap_8
XFILLER_27_7 VPWR VGND sg13g2_decap_8
XFILLER_2_473 VPWR VGND sg13g2_decap_8
XFILLER_34_8 VPWR VGND sg13g2_fill_2
XFILLER_49_81 VPWR VGND sg13g2_decap_8
XFILLER_18_330 VPWR VGND sg13g2_decap_8
XFILLER_1_77 VPWR VGND sg13g2_decap_8
XFILLER_33_300 VPWR VGND sg13g2_decap_8
XFILLER_46_672 VPWR VGND sg13g2_decap_8
XFILLER_14_580 VPWR VGND sg13g2_decap_8
XFILLER_33_377 VPWR VGND sg13g2_decap_8
XFILLER_45_182 VPWR VGND sg13g2_decap_8
X_0924_ net107 VGND VPWR _0084_ daisychain\[20\] clknet_5_4__leaf_clk sg13g2_dfrbpq_1
X_0855_ VPWR _0227_ daisychain\[34\] VGND sg13g2_inv_1
X_0786_ VPWR _0032_ state\[0\] VGND sg13g2_inv_1
XFILLER_28_116 VPWR VGND sg13g2_decap_8
XFILLER_24_344 VPWR VGND sg13g2_decap_8
XFILLER_36_160 VPWR VGND sg13g2_decap_8
XFILLER_43_119 VPWR VGND sg13g2_decap_8
XFILLER_44_609 VPWR VGND sg13g2_decap_8
XFILLER_45_28 VPWR VGND sg13g2_decap_8
XFILLER_20_561 VPWR VGND sg13g2_decap_8
XFILLER_10_20 VPWR VGND sg13g2_decap_8
XFILLER_10_97 VPWR VGND sg13g2_decap_8
XFILLER_15_300 VPWR VGND sg13g2_decap_8
XFILLER_19_105 VPWR VGND sg13g2_decap_8
XFILLER_19_84 VPWR VGND sg13g2_decap_8
XFILLER_47_469 VPWR VGND sg13g2_decap_8
XFILLER_15_377 VPWR VGND sg13g2_decap_8
XFILLER_27_182 VPWR VGND sg13g2_decap_8
XFILLER_30_347 VPWR VGND sg13g2_decap_8
XFILLER_42_196 VPWR VGND sg13g2_decap_8
X_0640_ _0237_ net70 _0390_ _0391_ VPWR VGND sg13g2_a21o_1
X_0571_ net82 VPWR _0339_ VGND net60 state\[27\] sg13g2_o21ai_1
XFILLER_7_598 VPWR VGND sg13g2_decap_4
XFILLER_7_532 VPWR VGND sg13g2_decap_8
XFILLER_25_4 VPWR VGND sg13g2_decap_8
XFILLER_2_270 VPWR VGND sg13g2_decap_8
XFILLER_38_447 VPWR VGND sg13g2_decap_8
XFILLER_3_782 VPWR VGND sg13g2_decap_8
XFILLER_19_672 VPWR VGND sg13g2_decap_8
X_1054_ daisychain\[62\] net21 VPWR VGND sg13g2_buf_1
XFILLER_21_358 VPWR VGND sg13g2_decap_8
XFILLER_33_174 VPWR VGND sg13g2_decap_8
X_0907_ net99 VGND VPWR _0067_ daisychain\[3\] clknet_5_12__leaf_clk sg13g2_dfrbpq_1
Xoutput19 net19 uo_out[4] VPWR VGND sg13g2_buf_1
X_0838_ VPWR _0050_ state\[26\] VGND sg13g2_inv_1
X_0769_ _0406_ VPWR _0177_ VGND net94 _0008_ sg13g2_o21ai_1
XFILLER_17_609 VPWR VGND sg13g2_decap_8
XFILLER_29_447 VPWR VGND sg13g2_decap_8
XFILLER_44_406 VPWR VGND sg13g2_decap_8
XFILLER_12_314 VPWR VGND sg13g2_decap_8
XFILLER_24_141 VPWR VGND sg13g2_decap_8
XFILLER_8_307 VPWR VGND sg13g2_decap_8
XFILLER_21_85 VPWR VGND sg13g2_decap_8
XFILLER_4_568 VPWR VGND sg13g2_fill_2
XFILLER_16_675 VPWR VGND sg13g2_fill_2
XFILLER_28_480 VPWR VGND sg13g2_decap_8
XFILLER_35_417 VPWR VGND sg13g2_decap_8
XFILLER_47_266 VPWR VGND sg13g2_decap_8
XFILLER_48_756 VPWR VGND sg13g2_decap_8
XFILLER_15_174 VPWR VGND sg13g2_decap_8
XFILLER_30_144 VPWR VGND sg13g2_decap_8
XFILLER_31_634 VPWR VGND sg13g2_fill_1
XFILLER_43_483 VPWR VGND sg13g2_decap_8
XFILLER_7_21 VPWR VGND sg13g2_decap_8
XFILLER_3_590 VPWR VGND sg13g2_decap_8
X_0623_ net88 VPWR _0378_ VGND net68 state\[40\] sg13g2_o21ai_1
X_0554_ _0086_ _0325_ _0326_ net42 _0215_ VPWR VGND sg13g2_a22oi_1
XFILLER_7_98 VPWR VGND sg13g2_decap_8
XFILLER_26_428 VPWR VGND sg13g2_decap_8
XFILLER_38_244 VPWR VGND sg13g2_decap_8
X_0485_ VGND VPWR net23 daisychain\[4\] _0275_ net37 sg13g2_a21oi_1
XFILLER_22_601 VPWR VGND sg13g2_decap_8
XFILLER_22_678 VPWR VGND sg13g2_decap_8
XFILLER_21_155 VPWR VGND sg13g2_decap_8
XFILLER_17_406 VPWR VGND sg13g2_decap_8
XFILLER_29_244 VPWR VGND sg13g2_decap_8
XFILLER_44_203 VPWR VGND sg13g2_decap_8
XFILLER_12_111 VPWR VGND sg13g2_decap_8
XFILLER_12_188 VPWR VGND sg13g2_decap_8
XFILLER_16_85 VPWR VGND sg13g2_decap_8
XFILLER_40_420 VPWR VGND sg13g2_decap_8
XFILLER_40_497 VPWR VGND sg13g2_decap_8
XFILLER_9_649 VPWR VGND sg13g2_fill_2
XFILLER_8_104 VPWR VGND sg13g2_decap_8
XFILLER_4_354 VPWR VGND sg13g2_decap_8
XFILLER_0_560 VPWR VGND sg13g2_decap_8
XFILLER_36_715 VPWR VGND sg13g2_fill_1
XFILLER_36_737 VPWR VGND sg13g2_decap_8
XFILLER_48_553 VPWR VGND sg13g2_decap_8
XFILLER_23_409 VPWR VGND sg13g2_decap_8
XFILLER_31_431 VPWR VGND sg13g2_decap_8
XFILLER_35_214 VPWR VGND sg13g2_decap_8
XFILLER_43_280 VPWR VGND sg13g2_decap_8
XFILLER_44_781 VPWR VGND sg13g2_decap_4
X_0606_ _0099_ _0364_ _0365_ net46 _0228_ VPWR VGND sg13g2_a22oi_1
X_0537_ VGND VPWR net25 daisychain\[17\] _0314_ net40 sg13g2_a21oi_1
XFILLER_26_225 VPWR VGND sg13g2_decap_8
XFILLER_37_29 VPWR VGND sg13g2_decap_8
XFILLER_39_597 VPWR VGND sg13g2_decap_8
X_0468_ _0194_ net57 _0261_ _0262_ VPWR VGND sg13g2_a21o_1
XFILLER_22_475 VPWR VGND sg13g2_decap_8
XFILLER_41_217 VPWR VGND sg13g2_decap_8
Xclkbuf_5_13__f_clk clknet_5_13__leaf_clk clknet_4_6_0_clk VPWR VGND sg13g2_buf_16
XFILLER_17_203 VPWR VGND sg13g2_decap_8
XFILLER_18_704 VPWR VGND sg13g2_fill_1
XFILLER_1_357 VPWR VGND sg13g2_decap_8
XFILLER_13_420 VPWR VGND sg13g2_decap_8
XFILLER_27_84 VPWR VGND sg13g2_decap_8
XFILLER_32_239 VPWR VGND sg13g2_decap_8
XFILLER_45_567 VPWR VGND sg13g2_decap_8
XFILLER_13_497 VPWR VGND sg13g2_decap_8
XFILLER_40_294 VPWR VGND sg13g2_decap_8
XFILLER_9_424 VPWR VGND sg13g2_decap_8
XFILLER_5_641 VPWR VGND sg13g2_fill_1
XFILLER_5_674 VPWR VGND sg13g2_fill_1
XFILLER_4_88 VPWR VGND sg13g2_decap_8
XFILLER_4_151 VPWR VGND sg13g2_decap_8
XFILLER_4_11 VPWR VGND sg13g2_decap_8
XFILLER_48_350 VPWR VGND sg13g2_decap_8
XFILLER_23_206 VPWR VGND sg13g2_decap_8
XFILLER_39_350 VPWR VGND sg13g2_decap_8
XFILLER_48_28 VPWR VGND sg13g2_decap_8
XFILLER_23_751 VPWR VGND sg13g2_decap_4
XFILLER_27_567 VPWR VGND sg13g2_decap_8
XFILLER_42_504 VPWR VGND sg13g2_decap_8
XFILLER_10_412 VPWR VGND sg13g2_decap_8
XFILLER_10_489 VPWR VGND sg13g2_decap_8
XFILLER_13_31 VPWR VGND sg13g2_decap_8
XFILLER_22_272 VPWR VGND sg13g2_decap_8
Xfanout32 _0192_ net32 VPWR VGND sg13g2_buf_1
Xfanout98 net119 net98 VPWR VGND sg13g2_buf_1
Xfanout87 net96 net87 VPWR VGND sg13g2_buf_1
Xfanout76 net77 net76 VPWR VGND sg13g2_buf_1
Xfanout65 net66 net65 VPWR VGND sg13g2_buf_1
Xfanout54 _0259_ net54 VPWR VGND sg13g2_buf_1
Xfanout43 net44 net43 VPWR VGND sg13g2_buf_1
XFILLER_1_154 VPWR VGND sg13g2_decap_8
XFILLER_2_666 VPWR VGND sg13g2_decap_4
XFILLER_18_512 VPWR VGND sg13g2_decap_8
XFILLER_38_83 VPWR VGND sg13g2_decap_8
XFILLER_49_158 VPWR VGND sg13g2_decap_8
XFILLER_13_283 VPWR VGND sg13g2_decap_8
XFILLER_18_589 VPWR VGND sg13g2_decap_8
XFILLER_33_559 VPWR VGND sg13g2_decap_8
XFILLER_41_581 VPWR VGND sg13g2_decap_8
XFILLER_45_364 VPWR VGND sg13g2_decap_8
X_0940_ net110 VGND VPWR _0100_ daisychain\[36\] clknet_5_25__leaf_clk sg13g2_dfrbpq_1
XFILLER_9_221 VPWR VGND sg13g2_decap_8
X_0871_ VPWR _0235_ daisychain\[42\] VGND sg13g2_inv_1
XFILLER_9_298 VPWR VGND sg13g2_decap_8
XFILLER_24_515 VPWR VGND sg13g2_decap_8
XFILLER_36_342 VPWR VGND sg13g2_decap_8
XFILLER_20_710 VPWR VGND sg13g2_fill_1
XFILLER_15_559 VPWR VGND sg13g2_decap_8
XFILLER_23_570 VPWR VGND sg13g2_decap_8
XFILLER_24_85 VPWR VGND sg13g2_decap_8
XFILLER_27_364 VPWR VGND sg13g2_decap_8
XFILLER_30_529 VPWR VGND sg13g2_decap_8
XFILLER_42_301 VPWR VGND sg13g2_decap_8
XFILLER_42_378 VPWR VGND sg13g2_decap_8
XFILLER_10_286 VPWR VGND sg13g2_decap_8
XFILLER_40_84 VPWR VGND sg13g2_decap_8
XFILLER_6_257 VPWR VGND sg13g2_decap_8
XFILLER_2_452 VPWR VGND sg13g2_decap_8
XFILLER_49_60 VPWR VGND sg13g2_decap_8
XFILLER_18_386 VPWR VGND sg13g2_decap_8
XFILLER_19_821 VPWR VGND sg13g2_fill_2
XFILLER_1_56 VPWR VGND sg13g2_decap_8
XFILLER_37_139 VPWR VGND sg13g2_decap_8
XFILLER_45_161 VPWR VGND sg13g2_decap_8
XFILLER_46_651 VPWR VGND sg13g2_decap_8
XFILLER_33_356 VPWR VGND sg13g2_decap_8
X_0854_ VPWR _0022_ state\[34\] VGND sg13g2_inv_1
X_0923_ net107 VGND VPWR _0083_ daisychain\[19\] clknet_5_20__leaf_clk sg13g2_dfrbpq_1
XFILLER_46_0 VPWR VGND sg13g2_decap_8
X_0785_ VPWR _0192_ net76 VGND sg13g2_inv_1
XFILLER_29_629 VPWR VGND sg13g2_decap_8
XFILLER_12_529 VPWR VGND sg13g2_decap_8
XFILLER_24_323 VPWR VGND sg13g2_decap_8
XFILLER_20_540 VPWR VGND sg13g2_decap_8
XFILLER_10_76 VPWR VGND sg13g2_decap_8
XFILLER_3_249 VPWR VGND sg13g2_decap_8
XFILLER_19_63 VPWR VGND sg13g2_decap_8
XFILLER_27_161 VPWR VGND sg13g2_decap_8
XFILLER_47_448 VPWR VGND sg13g2_decap_8
XFILLER_11_584 VPWR VGND sg13g2_decap_8
XFILLER_15_356 VPWR VGND sg13g2_decap_8
XFILLER_30_326 VPWR VGND sg13g2_decap_8
XFILLER_31_816 VPWR VGND sg13g2_decap_8
XFILLER_35_95 VPWR VGND sg13g2_decap_8
XFILLER_42_175 VPWR VGND sg13g2_decap_8
XFILLER_7_511 VPWR VGND sg13g2_decap_8
XFILLER_11_595 VPWR VGND sg13g2_fill_1
X_0570_ _0090_ _0337_ _0338_ net37 _0219_ VPWR VGND sg13g2_a22oi_1
XFILLER_19_651 VPWR VGND sg13g2_decap_8
XFILLER_38_426 VPWR VGND sg13g2_decap_8
XFILLER_18_183 VPWR VGND sg13g2_decap_8
XFILLER_21_337 VPWR VGND sg13g2_decap_8
XFILLER_22_816 VPWR VGND sg13g2_decap_8
XFILLER_33_153 VPWR VGND sg13g2_decap_8
XFILLER_34_698 VPWR VGND sg13g2_fill_2
X_1053_ daisychain\[61\] net20 VPWR VGND sg13g2_buf_1
X_0906_ net99 VGND VPWR _0066_ daisychain\[2\] clknet_5_9__leaf_clk sg13g2_dfrbpq_1
X_0837_ VPWR _0218_ daisychain\[25\] VGND sg13g2_inv_1
X_0768_ _0403_ VPWR _0176_ VGND net94 _0007_ sg13g2_o21ai_1
X_0699_ net77 VPWR _0435_ VGND net56 state\[59\] sg13g2_o21ai_1
XFILLER_24_120 VPWR VGND sg13g2_decap_8
XFILLER_25_610 VPWR VGND sg13g2_decap_8
XFILLER_25_621 VPWR VGND sg13g2_fill_2
XFILLER_29_426 VPWR VGND sg13g2_decap_8
XFILLER_24_197 VPWR VGND sg13g2_decap_8
XFILLER_25_676 VPWR VGND sg13g2_decap_4
XFILLER_40_602 VPWR VGND sg13g2_decap_4
XFILLER_21_64 VPWR VGND sg13g2_decap_8
XFILLER_4_536 VPWR VGND sg13g2_fill_2
XFILLER_0_742 VPWR VGND sg13g2_fill_1
XFILLER_47_245 VPWR VGND sg13g2_decap_8
XFILLER_48_735 VPWR VGND sg13g2_decap_8
XFILLER_15_153 VPWR VGND sg13g2_decap_8
XFILLER_16_610 VPWR VGND sg13g2_decap_8
XFILLER_16_621 VPWR VGND sg13g2_fill_2
XFILLER_16_698 VPWR VGND sg13g2_decap_8
XFILLER_31_613 VPWR VGND sg13g2_decap_8
XFILLER_43_462 VPWR VGND sg13g2_decap_8
XFILLER_30_123 VPWR VGND sg13g2_decap_8
XFILLER_31_657 VPWR VGND sg13g2_decap_4
XFILLER_7_77 VPWR VGND sg13g2_decap_8
X_0622_ _0103_ _0376_ _0377_ net50 _0232_ VPWR VGND sg13g2_a22oi_1
X_0553_ VGND VPWR net25 daisychain\[21\] _0326_ net42 sg13g2_a21oi_1
X_0484_ _0198_ net59 _0273_ _0274_ VPWR VGND sg13g2_a21o_1
XFILLER_7_385 VPWR VGND sg13g2_decap_8
XFILLER_26_407 VPWR VGND sg13g2_decap_8
XFILLER_38_223 VPWR VGND sg13g2_decap_8
XFILLER_21_134 VPWR VGND sg13g2_decap_8
XFILLER_22_657 VPWR VGND sg13g2_decap_8
XFILLER_34_495 VPWR VGND sg13g2_decap_8
XFILLER_1_539 VPWR VGND sg13g2_decap_8
XFILLER_29_223 VPWR VGND sg13g2_decap_8
XFILLER_13_602 VPWR VGND sg13g2_decap_4
XFILLER_13_624 VPWR VGND sg13g2_decap_4
XFILLER_16_64 VPWR VGND sg13g2_decap_8
XFILLER_25_484 VPWR VGND sg13g2_decap_8
XFILLER_44_259 VPWR VGND sg13g2_decap_8
XFILLER_12_167 VPWR VGND sg13g2_decap_8
XFILLER_13_668 VPWR VGND sg13g2_fill_2
XFILLER_32_85 VPWR VGND sg13g2_decap_8
XFILLER_40_476 VPWR VGND sg13g2_decap_8
XFILLER_9_606 VPWR VGND sg13g2_fill_1
XFILLER_4_333 VPWR VGND sg13g2_decap_8
XFILLER_48_532 VPWR VGND sg13g2_decap_8
XFILLER_16_484 VPWR VGND sg13g2_decap_8
XFILLER_31_410 VPWR VGND sg13g2_decap_8
XFILLER_31_487 VPWR VGND sg13g2_decap_8
XFILLER_7_182 VPWR VGND sg13g2_decap_8
X_0605_ VGND VPWR net29 daisychain\[34\] _0365_ net46 sg13g2_a21oi_1
X_0536_ _0211_ net63 _0312_ _0313_ VPWR VGND sg13g2_a21o_1
X_0467_ net78 VPWR _0261_ VGND net57 state\[1\] sg13g2_o21ai_1
XFILLER_26_204 VPWR VGND sg13g2_decap_8
XFILLER_27_705 VPWR VGND sg13g2_decap_8
XFILLER_39_576 VPWR VGND sg13g2_decap_8
XFILLER_42_719 VPWR VGND sg13g2_fill_1
X_1019_ net115 VGND VPWR _0179_ state\[51\] clknet_5_31__leaf_clk sg13g2_dfrbpq_1
XFILLER_22_454 VPWR VGND sg13g2_decap_8
XFILLER_34_292 VPWR VGND sg13g2_decap_8
XFILLER_1_336 VPWR VGND sg13g2_decap_8
XFILLER_27_63 VPWR VGND sg13g2_decap_8
XFILLER_45_546 VPWR VGND sg13g2_decap_8
XFILLER_13_476 VPWR VGND sg13g2_decap_8
XFILLER_17_259 VPWR VGND sg13g2_decap_8
XFILLER_25_281 VPWR VGND sg13g2_decap_8
XFILLER_32_218 VPWR VGND sg13g2_decap_8
XFILLER_9_403 VPWR VGND sg13g2_decap_8
XFILLER_40_273 VPWR VGND sg13g2_decap_8
XFILLER_43_84 VPWR VGND sg13g2_decap_8
XFILLER_5_631 VPWR VGND sg13g2_fill_2
XFILLER_4_130 VPWR VGND sg13g2_decap_8
XFILLER_4_67 VPWR VGND sg13g2_decap_8
XFILLER_36_524 VPWR VGND sg13g2_decap_8
XFILLER_36_535 VPWR VGND sg13g2_fill_2
XFILLER_16_281 VPWR VGND sg13g2_decap_8
XFILLER_31_284 VPWR VGND sg13g2_decap_8
XFILLER_32_796 VPWR VGND sg13g2_decap_8
X_0519_ net84 VPWR _0300_ VGND net62 state\[14\] sg13g2_o21ai_1
XFILLER_22_251 VPWR VGND sg13g2_decap_8
XFILLER_23_730 VPWR VGND sg13g2_decap_8
XFILLER_23_774 VPWR VGND sg13g2_decap_4
XFILLER_27_546 VPWR VGND sg13g2_decap_8
Xfanout33 net54 net33 VPWR VGND sg13g2_buf_1
Xfanout55 net5 net55 VPWR VGND sg13g2_buf_1
Xfanout44 net53 net44 VPWR VGND sg13g2_buf_1
XFILLER_10_468 VPWR VGND sg13g2_decap_8
XFILLER_13_87 VPWR VGND sg13g2_decap_8
Xfanout99 net100 net99 VPWR VGND sg13g2_buf_1
Xfanout88 net89 net88 VPWR VGND sg13g2_buf_1
Xfanout77 net4 net77 VPWR VGND sg13g2_buf_1
Xfanout66 net75 net66 VPWR VGND sg13g2_buf_1
XFILLER_6_439 VPWR VGND sg13g2_decap_8
XFILLER_1_133 VPWR VGND sg13g2_decap_8
XFILLER_49_137 VPWR VGND sg13g2_decap_8
XFILLER_18_568 VPWR VGND sg13g2_decap_8
XFILLER_38_62 VPWR VGND sg13g2_decap_8
XFILLER_45_343 VPWR VGND sg13g2_decap_8
XFILLER_46_822 VPWR VGND sg13g2_fill_1
XFILLER_13_262 VPWR VGND sg13g2_decap_8
XFILLER_33_538 VPWR VGND sg13g2_decap_8
XFILLER_41_560 VPWR VGND sg13g2_decap_8
X_0870_ VPWR _0001_ state\[42\] VGND sg13g2_inv_1
XFILLER_9_277 VPWR VGND sg13g2_decap_8
XFILLER_9_200 VPWR VGND sg13g2_decap_8
XFILLER_5_494 VPWR VGND sg13g2_decap_8
XFILLER_36_321 VPWR VGND sg13g2_decap_8
XFILLER_36_398 VPWR VGND sg13g2_decap_8
XFILLER_20_799 VPWR VGND sg13g2_decap_8
XFILLER_32_582 VPWR VGND sg13g2_decap_8
X_0999_ net107 VGND VPWR _0159_ state\[31\] clknet_5_21__leaf_clk sg13g2_dfrbpq_1
XFILLER_27_343 VPWR VGND sg13g2_decap_8
XFILLER_28_811 VPWR VGND sg13g2_decap_8
XFILLER_28_822 VPWR VGND sg13g2_fill_1
XFILLER_15_538 VPWR VGND sg13g2_decap_8
XFILLER_24_64 VPWR VGND sg13g2_decap_8
XFILLER_30_508 VPWR VGND sg13g2_decap_8
XFILLER_42_357 VPWR VGND sg13g2_decap_8
XFILLER_10_265 VPWR VGND sg13g2_decap_8
XFILLER_2_431 VPWR VGND sg13g2_decap_8
XFILLER_40_63 VPWR VGND sg13g2_decap_8
XFILLER_6_236 VPWR VGND sg13g2_decap_8
XFILLER_1_35 VPWR VGND sg13g2_decap_8
XFILLER_37_118 VPWR VGND sg13g2_decap_8
XFILLER_18_365 VPWR VGND sg13g2_decap_8
XFILLER_21_519 VPWR VGND sg13g2_decap_8
XFILLER_33_335 VPWR VGND sg13g2_decap_8
XFILLER_45_140 VPWR VGND sg13g2_decap_8
XFILLER_46_630 VPWR VGND sg13g2_decap_8
X_0853_ VPWR _0226_ daisychain\[33\] VGND sg13g2_inv_1
X_0922_ net106 VGND VPWR _0082_ daisychain\[18\] clknet_5_21__leaf_clk sg13g2_dfrbpq_1
XFILLER_39_0 VPWR VGND sg13g2_decap_8
X_0784_ _0449_ VPWR _0191_ VGND net76 _0024_ sg13g2_o21ai_1
XFILLER_5_291 VPWR VGND sg13g2_decap_8
XFILLER_24_302 VPWR VGND sg13g2_decap_8
XFILLER_25_814 VPWR VGND sg13g2_decap_8
XFILLER_29_608 VPWR VGND sg13g2_decap_8
Xinput1 rst_n net1 VPWR VGND sg13g2_buf_1
XFILLER_12_508 VPWR VGND sg13g2_decap_8
XFILLER_24_379 VPWR VGND sg13g2_decap_8
XFILLER_36_195 VPWR VGND sg13g2_decap_8
XFILLER_10_55 VPWR VGND sg13g2_decap_8
XFILLER_20_596 VPWR VGND sg13g2_decap_8
XFILLER_3_228 VPWR VGND sg13g2_decap_8
XFILLER_19_42 VPWR VGND sg13g2_decap_8
XFILLER_47_427 VPWR VGND sg13g2_decap_8
XFILLER_15_335 VPWR VGND sg13g2_decap_8
XFILLER_27_140 VPWR VGND sg13g2_decap_8
XFILLER_28_641 VPWR VGND sg13g2_decap_8
XFILLER_35_74 VPWR VGND sg13g2_decap_8
XFILLER_42_154 VPWR VGND sg13g2_decap_8
XFILLER_43_644 VPWR VGND sg13g2_decap_8
XFILLER_43_666 VPWR VGND sg13g2_decap_8
XFILLER_11_563 VPWR VGND sg13g2_decap_8
XFILLER_30_305 VPWR VGND sg13g2_decap_8
XFILLER_19_630 VPWR VGND sg13g2_decap_8
XFILLER_34_600 VPWR VGND sg13g2_decap_8
XFILLER_38_405 VPWR VGND sg13g2_decap_8
X_1052_ daisychain\[60\] net19 VPWR VGND sg13g2_buf_1
XFILLER_18_162 VPWR VGND sg13g2_decap_8
XFILLER_21_316 VPWR VGND sg13g2_decap_8
XFILLER_33_132 VPWR VGND sg13g2_decap_8
X_0905_ net99 VGND VPWR _0065_ daisychain\[1\] clknet_5_10__leaf_clk sg13g2_dfrbpq_1
X_0836_ VPWR _0049_ state\[25\] VGND sg13g2_inv_1
X_0767_ _0400_ VPWR _0175_ VGND net92 _0006_ sg13g2_o21ai_1
XFILLER_29_405 VPWR VGND sg13g2_decap_8
X_0698_ _0122_ _0433_ _0434_ net34 _0251_ VPWR VGND sg13g2_a22oi_1
XFILLER_25_655 VPWR VGND sg13g2_decap_8
XFILLER_12_349 VPWR VGND sg13g2_decap_8
XFILLER_20_393 VPWR VGND sg13g2_decap_8
XFILLER_24_176 VPWR VGND sg13g2_decap_8
XFILLER_21_43 VPWR VGND sg13g2_decap_8
XFILLER_4_515 VPWR VGND sg13g2_decap_8
XFILLER_47_224 VPWR VGND sg13g2_decap_8
XFILLER_48_714 VPWR VGND sg13g2_decap_8
XFILLER_15_132 VPWR VGND sg13g2_decap_8
XFILLER_16_677 VPWR VGND sg13g2_fill_1
XFILLER_30_102 VPWR VGND sg13g2_decap_8
XFILLER_43_441 VPWR VGND sg13g2_decap_8
XFILLER_46_84 VPWR VGND sg13g2_decap_8
Xclkbuf_5_0__f_clk clknet_5_0__leaf_clk clknet_4_0_0_clk VPWR VGND sg13g2_buf_16
XFILLER_11_382 VPWR VGND sg13g2_decap_8
XFILLER_30_179 VPWR VGND sg13g2_decap_8
X_0621_ VGND VPWR net28 daisychain\[38\] _0377_ net50 sg13g2_a21oi_1
XFILLER_7_56 VPWR VGND sg13g2_decap_8
XFILLER_7_364 VPWR VGND sg13g2_decap_8
XFILLER_30_4 VPWR VGND sg13g2_decap_4
XFILLER_38_202 VPWR VGND sg13g2_decap_8
XFILLER_39_736 VPWR VGND sg13g2_decap_4
X_0552_ _0215_ net64 _0324_ _0325_ VPWR VGND sg13g2_a21o_1
X_0483_ net79 VPWR _0273_ VGND net59 state\[5\] sg13g2_o21ai_1
XFILLER_38_279 VPWR VGND sg13g2_decap_8
XFILLER_47_791 VPWR VGND sg13g2_decap_4
XFILLER_21_113 VPWR VGND sg13g2_decap_8
XFILLER_22_636 VPWR VGND sg13g2_decap_8
XFILLER_30_680 VPWR VGND sg13g2_decap_8
XFILLER_34_474 VPWR VGND sg13g2_decap_8
XFILLER_1_518 VPWR VGND sg13g2_decap_8
X_0819_ VPWR _0209_ daisychain\[16\] VGND sg13g2_inv_1
XFILLER_29_202 VPWR VGND sg13g2_decap_8
XFILLER_29_279 VPWR VGND sg13g2_decap_8
XFILLER_16_43 VPWR VGND sg13g2_decap_8
XFILLER_25_463 VPWR VGND sg13g2_decap_8
XFILLER_44_238 VPWR VGND sg13g2_decap_8
XFILLER_12_146 VPWR VGND sg13g2_decap_8
XFILLER_20_190 VPWR VGND sg13g2_decap_8
XFILLER_21_680 VPWR VGND sg13g2_decap_8
XFILLER_32_64 VPWR VGND sg13g2_decap_8
XFILLER_40_455 VPWR VGND sg13g2_decap_8
XFILLER_8_139 VPWR VGND sg13g2_decap_8
XFILLER_4_312 VPWR VGND sg13g2_decap_8
XFILLER_4_389 VPWR VGND sg13g2_decap_8
XFILLER_48_511 VPWR VGND sg13g2_decap_8
XFILLER_35_249 VPWR VGND sg13g2_decap_8
XFILLER_48_588 VPWR VGND sg13g2_decap_8
XFILLER_16_463 VPWR VGND sg13g2_decap_8
XFILLER_31_466 VPWR VGND sg13g2_decap_8
X_0604_ _0228_ net67 _0363_ _0364_ VPWR VGND sg13g2_a21o_1
XFILLER_8_684 VPWR VGND sg13g2_fill_1
XFILLER_7_161 VPWR VGND sg13g2_decap_8
XFILLER_21_0 VPWR VGND sg13g2_fill_2
XFILLER_27_717 VPWR VGND sg13g2_fill_2
XFILLER_39_555 VPWR VGND sg13g2_decap_8
X_0535_ net85 VPWR _0312_ VGND net63 state\[18\] sg13g2_o21ai_1
X_0466_ _0064_ _0260_ _0258_ net35 _0193_ VPWR VGND sg13g2_a22oi_1
XFILLER_22_433 VPWR VGND sg13g2_decap_8
XFILLER_34_271 VPWR VGND sg13g2_decap_8
X_1018_ net116 VGND VPWR _0178_ state\[50\] clknet_5_28__leaf_clk sg13g2_dfrbpq_1
XFILLER_5_109 VPWR VGND sg13g2_decap_8
XFILLER_1_315 VPWR VGND sg13g2_decap_8
XFILLER_49_319 VPWR VGND sg13g2_decap_8
XFILLER_17_238 VPWR VGND sg13g2_decap_8
XFILLER_18_717 VPWR VGND sg13g2_decap_8
XFILLER_27_42 VPWR VGND sg13g2_decap_8
XFILLER_45_525 VPWR VGND sg13g2_decap_8
XFILLER_13_455 VPWR VGND sg13g2_decap_8
XFILLER_25_260 VPWR VGND sg13g2_decap_8
XFILLER_40_252 VPWR VGND sg13g2_decap_8
XFILLER_41_731 VPWR VGND sg13g2_fill_2
XFILLER_43_63 VPWR VGND sg13g2_decap_8
XFILLER_9_459 VPWR VGND sg13g2_decap_8
XFILLER_5_610 VPWR VGND sg13g2_decap_8
XFILLER_0_392 VPWR VGND sg13g2_decap_8
XFILLER_36_503 VPWR VGND sg13g2_decap_8
XFILLER_4_46 VPWR VGND sg13g2_decap_8
XFILLER_4_186 VPWR VGND sg13g2_decap_8
XFILLER_16_260 VPWR VGND sg13g2_decap_8
XFILLER_17_761 VPWR VGND sg13g2_decap_4
XFILLER_36_569 VPWR VGND sg13g2_decap_8
XFILLER_48_385 VPWR VGND sg13g2_decap_8
XFILLER_31_263 VPWR VGND sg13g2_decap_8
X_0518_ _0077_ _0298_ _0299_ net39 _0206_ VPWR VGND sg13g2_a22oi_1
XFILLER_27_525 VPWR VGND sg13g2_decap_8
XFILLER_39_385 VPWR VGND sg13g2_decap_8
XFILLER_22_230 VPWR VGND sg13g2_decap_8
XFILLER_42_539 VPWR VGND sg13g2_decap_8
Xfanout23 net24 net23 VPWR VGND sg13g2_buf_1
Xfanout34 net54 net34 VPWR VGND sg13g2_buf_1
Xfanout89 net96 net89 VPWR VGND sg13g2_buf_1
Xfanout78 net97 net78 VPWR VGND sg13g2_buf_1
Xfanout67 net68 net67 VPWR VGND sg13g2_buf_1
Xfanout56 net5 net56 VPWR VGND sg13g2_buf_1
Xfanout45 net47 net45 VPWR VGND sg13g2_buf_1
XFILLER_10_447 VPWR VGND sg13g2_decap_8
XFILLER_13_66 VPWR VGND sg13g2_decap_8
XFILLER_6_418 VPWR VGND sg13g2_decap_8
XFILLER_1_112 VPWR VGND sg13g2_decap_8
XFILLER_1_189 VPWR VGND sg13g2_decap_8
XFILLER_2_635 VPWR VGND sg13g2_fill_2
XFILLER_8_4 VPWR VGND sg13g2_decap_4
XFILLER_49_116 VPWR VGND sg13g2_decap_8
XFILLER_18_547 VPWR VGND sg13g2_decap_8
XFILLER_33_517 VPWR VGND sg13g2_decap_8
XFILLER_45_322 VPWR VGND sg13g2_decap_8
XFILLER_45_399 VPWR VGND sg13g2_decap_8
XFILLER_13_241 VPWR VGND sg13g2_decap_8
XFILLER_9_256 VPWR VGND sg13g2_decap_8
XFILLER_5_473 VPWR VGND sg13g2_decap_8
XFILLER_36_300 VPWR VGND sg13g2_decap_8
XFILLER_48_182 VPWR VGND sg13g2_decap_8
XFILLER_49_683 VPWR VGND sg13g2_decap_8
XFILLER_32_561 VPWR VGND sg13g2_decap_8
XFILLER_36_377 VPWR VGND sg13g2_decap_8
X_0998_ net107 VGND VPWR _0158_ state\[30\] clknet_5_4__leaf_clk sg13g2_dfrbpq_1
XFILLER_47_609 VPWR VGND sg13g2_decap_8
XFILLER_15_517 VPWR VGND sg13g2_decap_8
XFILLER_27_322 VPWR VGND sg13g2_decap_8
XFILLER_27_399 VPWR VGND sg13g2_decap_8
XFILLER_39_182 VPWR VGND sg13g2_decap_8
XFILLER_42_336 VPWR VGND sg13g2_decap_8
XFILLER_46_119 VPWR VGND sg13g2_decap_8
XFILLER_10_244 VPWR VGND sg13g2_decap_8
XFILLER_11_734 VPWR VGND sg13g2_decap_8
XFILLER_24_43 VPWR VGND sg13g2_decap_8
XFILLER_6_215 VPWR VGND sg13g2_decap_8
XFILLER_2_410 VPWR VGND sg13g2_decap_8
XFILLER_40_42 VPWR VGND sg13g2_decap_8
XFILLER_18_344 VPWR VGND sg13g2_decap_8
XFILLER_1_14 VPWR VGND sg13g2_decap_8
XFILLER_2_487 VPWR VGND sg13g2_decap_8
XFILLER_49_95 VPWR VGND sg13g2_decap_8
XFILLER_33_314 VPWR VGND sg13g2_decap_8
XFILLER_45_196 VPWR VGND sg13g2_decap_8
XFILLER_46_686 VPWR VGND sg13g2_decap_8
X_0921_ net106 VGND VPWR _0081_ daisychain\[17\] clknet_5_4__leaf_clk sg13g2_dfrbpq_1
XFILLER_14_594 VPWR VGND sg13g2_decap_8
X_0852_ VPWR _0011_ state\[33\] VGND sg13g2_inv_1
X_0783_ _0451_ VPWR _0190_ VGND _0444_ _0445_ sg13g2_o21ai_1
XFILLER_5_270 VPWR VGND sg13g2_decap_8
XFILLER_36_174 VPWR VGND sg13g2_decap_8
XFILLER_37_686 VPWR VGND sg13g2_decap_8
XFILLER_37_697 VPWR VGND sg13g2_fill_2
Xinput2 ui_in[0] net2 VPWR VGND sg13g2_buf_1
XFILLER_49_480 VPWR VGND sg13g2_decap_8
XFILLER_20_575 VPWR VGND sg13g2_decap_8
XFILLER_24_358 VPWR VGND sg13g2_decap_8
XFILLER_10_34 VPWR VGND sg13g2_decap_8
XFILLER_3_207 VPWR VGND sg13g2_decap_8
XFILLER_4_708 VPWR VGND sg13g2_fill_2
XFILLER_19_119 VPWR VGND sg13g2_decap_8
XFILLER_19_98 VPWR VGND sg13g2_decap_8
XFILLER_28_620 VPWR VGND sg13g2_decap_8
XFILLER_47_406 VPWR VGND sg13g2_decap_8
XFILLER_15_314 VPWR VGND sg13g2_decap_8
XFILLER_27_196 VPWR VGND sg13g2_decap_8
XFILLER_35_53 VPWR VGND sg13g2_decap_8
XFILLER_42_133 VPWR VGND sg13g2_decap_8
XFILLER_43_623 VPWR VGND sg13g2_decap_8
XFILLER_11_542 VPWR VGND sg13g2_decap_8
Xclkbuf_5_19__f_clk clknet_5_19__leaf_clk clknet_4_9_0_clk VPWR VGND sg13g2_buf_16
XFILLER_7_546 VPWR VGND sg13g2_decap_8
XFILLER_2_284 VPWR VGND sg13g2_decap_8
XFILLER_3_796 VPWR VGND sg13g2_fill_2
XFILLER_18_141 VPWR VGND sg13g2_decap_8
XFILLER_33_111 VPWR VGND sg13g2_decap_8
XFILLER_46_483 VPWR VGND sg13g2_decap_8
X_1051_ daisychain\[59\] net18 VPWR VGND sg13g2_buf_1
XFILLER_14_391 VPWR VGND sg13g2_decap_8
XFILLER_33_188 VPWR VGND sg13g2_decap_8
XFILLER_34_667 VPWR VGND sg13g2_fill_1
X_0904_ net99 VGND VPWR _0064_ daisychain\[0\] clknet_5_8__leaf_clk sg13g2_dfrbpq_1
X_0835_ VPWR _0217_ daisychain\[24\] VGND sg13g2_inv_1
X_0766_ _0397_ VPWR _0174_ VGND net92 _0005_ sg13g2_o21ai_1
X_0697_ VGND VPWR net32 daisychain\[57\] _0434_ net34 sg13g2_a21oi_1
XFILLER_13_807 VPWR VGND sg13g2_fill_1
XFILLER_13_818 VPWR VGND sg13g2_fill_2
XFILLER_24_155 VPWR VGND sg13g2_decap_8
XFILLER_37_461 VPWR VGND sg13g2_decap_4
XFILLER_12_328 VPWR VGND sg13g2_decap_8
XFILLER_20_372 VPWR VGND sg13g2_decap_8
XFILLER_0_755 VPWR VGND sg13g2_decap_8
XFILLER_21_99 VPWR VGND sg13g2_decap_8
XFILLER_0_766 VPWR VGND sg13g2_fill_1
XFILLER_0_777 VPWR VGND sg13g2_decap_8
XFILLER_16_634 VPWR VGND sg13g2_decap_8
XFILLER_28_494 VPWR VGND sg13g2_decap_8
XFILLER_46_63 VPWR VGND sg13g2_decap_8
XFILLER_47_203 VPWR VGND sg13g2_decap_8
XFILLER_15_111 VPWR VGND sg13g2_decap_8
XFILLER_15_188 VPWR VGND sg13g2_decap_8
XFILLER_30_158 VPWR VGND sg13g2_decap_8
XFILLER_43_420 VPWR VGND sg13g2_decap_8
XFILLER_43_497 VPWR VGND sg13g2_decap_8
XFILLER_11_361 VPWR VGND sg13g2_decap_8
X_0620_ _0232_ net71 _0375_ _0376_ VPWR VGND sg13g2_a21o_1
X_0551_ net86 VPWR _0324_ VGND net64 state\[22\] sg13g2_o21ai_1
XFILLER_7_35 VPWR VGND sg13g2_decap_8
XFILLER_7_343 VPWR VGND sg13g2_decap_8
XFILLER_23_4 VPWR VGND sg13g2_decap_8
XFILLER_39_704 VPWR VGND sg13g2_fill_2
XFILLER_39_715 VPWR VGND sg13g2_decap_4
X_0482_ _0068_ _0271_ _0272_ net37 _0197_ VPWR VGND sg13g2_a22oi_1
XFILLER_19_483 VPWR VGND sg13g2_decap_8
XFILLER_22_615 VPWR VGND sg13g2_decap_8
XFILLER_34_453 VPWR VGND sg13g2_decap_8
XFILLER_38_258 VPWR VGND sg13g2_decap_8
XFILLER_46_280 VPWR VGND sg13g2_decap_8
XFILLER_21_169 VPWR VGND sg13g2_decap_8
X_0818_ VPWR _0039_ state\[16\] VGND sg13g2_inv_1
X_0749_ _0346_ VPWR _0157_ VGND net82 _0053_ sg13g2_o21ai_1
XFILLER_29_258 VPWR VGND sg13g2_decap_8
XFILLER_44_217 VPWR VGND sg13g2_decap_8
XFILLER_12_125 VPWR VGND sg13g2_decap_8
XFILLER_16_99 VPWR VGND sg13g2_decap_8
XFILLER_25_442 VPWR VGND sg13g2_decap_8
XFILLER_40_434 VPWR VGND sg13g2_decap_8
XFILLER_8_118 VPWR VGND sg13g2_decap_8
XFILLER_32_43 VPWR VGND sg13g2_decap_8
XFILLER_0_574 VPWR VGND sg13g2_decap_8
XFILLER_4_368 VPWR VGND sg13g2_decap_8
XFILLER_16_442 VPWR VGND sg13g2_decap_8
XFILLER_28_291 VPWR VGND sg13g2_decap_8
XFILLER_35_228 VPWR VGND sg13g2_decap_8
XFILLER_48_567 VPWR VGND sg13g2_decap_8
XFILLER_31_445 VPWR VGND sg13g2_decap_8
XFILLER_43_294 VPWR VGND sg13g2_decap_8
XFILLER_44_795 VPWR VGND sg13g2_decap_4
XFILLER_7_140 VPWR VGND sg13g2_decap_8
X_0603_ net88 VPWR _0363_ VGND net67 state\[35\] sg13g2_o21ai_1
X_0534_ _0081_ _0310_ _0311_ net40 _0210_ VPWR VGND sg13g2_a22oi_1
X_0465_ VGND VPWR net31 net2 _0260_ net35 sg13g2_a21oi_1
XFILLER_19_280 VPWR VGND sg13g2_decap_8
XFILLER_22_412 VPWR VGND sg13g2_decap_8
XFILLER_26_239 VPWR VGND sg13g2_decap_8
XFILLER_34_250 VPWR VGND sg13g2_decap_8
X_1017_ net116 VGND VPWR _0177_ state\[49\] clknet_5_28__leaf_clk sg13g2_dfrbpq_1
XFILLER_22_489 VPWR VGND sg13g2_decap_8
XFILLER_17_217 VPWR VGND sg13g2_decap_8
XFILLER_27_21 VPWR VGND sg13g2_decap_8
XFILLER_27_98 VPWR VGND sg13g2_decap_8
XFILLER_45_504 VPWR VGND sg13g2_decap_8
XFILLER_13_434 VPWR VGND sg13g2_decap_8
XFILLER_40_231 VPWR VGND sg13g2_decap_8
XFILLER_43_42 VPWR VGND sg13g2_decap_8
XFILLER_9_438 VPWR VGND sg13g2_decap_8
XFILLER_5_633 VPWR VGND sg13g2_fill_1
XFILLER_4_25 VPWR VGND sg13g2_decap_8
XFILLER_4_165 VPWR VGND sg13g2_decap_8
XFILLER_0_371 VPWR VGND sg13g2_decap_8
XFILLER_48_364 VPWR VGND sg13g2_decap_8
XFILLER_31_242 VPWR VGND sg13g2_decap_8
XFILLER_44_581 VPWR VGND sg13g2_decap_8
XFILLER_8_482 VPWR VGND sg13g2_decap_8
X_0517_ VGND VPWR net26 daisychain\[12\] _0299_ net39 sg13g2_a21oi_1
XFILLER_14_209 VPWR VGND sg13g2_decap_8
XFILLER_27_504 VPWR VGND sg13g2_decap_8
XFILLER_39_364 VPWR VGND sg13g2_decap_8
XFILLER_42_518 VPWR VGND sg13g2_decap_8
XFILLER_10_426 VPWR VGND sg13g2_decap_8
XFILLER_13_45 VPWR VGND sg13g2_decap_8
XFILLER_22_286 VPWR VGND sg13g2_decap_8
XFILLER_23_765 VPWR VGND sg13g2_fill_2
XFILLER_35_592 VPWR VGND sg13g2_decap_8
Xfanout24 net30 net24 VPWR VGND sg13g2_buf_1
Xfanout79 net81 net79 VPWR VGND sg13g2_buf_1
Xfanout68 net74 net68 VPWR VGND sg13g2_buf_1
Xfanout57 net75 net57 VPWR VGND sg13g2_buf_1
Xfanout46 net53 net46 VPWR VGND sg13g2_buf_1
Xfanout35 net54 net35 VPWR VGND sg13g2_buf_1
XFILLER_18_526 VPWR VGND sg13g2_decap_8
XFILLER_1_168 VPWR VGND sg13g2_decap_8
XFILLER_38_42 VPWR VGND sg13g2_decap_4
XFILLER_38_97 VPWR VGND sg13g2_decap_8
XFILLER_45_301 VPWR VGND sg13g2_decap_8
XFILLER_13_220 VPWR VGND sg13g2_decap_8
XFILLER_14_732 VPWR VGND sg13g2_fill_2
XFILLER_45_378 VPWR VGND sg13g2_decap_8
XFILLER_13_297 VPWR VGND sg13g2_decap_8
XFILLER_41_595 VPWR VGND sg13g2_decap_8
XFILLER_9_235 VPWR VGND sg13g2_decap_8
Xdigitalen.g\[1\].u.inv1 VPWR digitalen.g\[1\].u.OUTN net6 VGND sg13g2_inv_1
XFILLER_5_452 VPWR VGND sg13g2_decap_8
XFILLER_36_356 VPWR VGND sg13g2_decap_8
XFILLER_48_161 VPWR VGND sg13g2_decap_8
XFILLER_49_662 VPWR VGND sg13g2_decap_8
XFILLER_17_581 VPWR VGND sg13g2_decap_8
XFILLER_24_529 VPWR VGND sg13g2_decap_8
XFILLER_32_540 VPWR VGND sg13g2_decap_8
X_0997_ net118 VGND VPWR _0157_ state\[29\] clknet_5_6__leaf_clk sg13g2_dfrbpq_1
XFILLER_27_301 VPWR VGND sg13g2_decap_8
XFILLER_39_161 VPWR VGND sg13g2_decap_8
XFILLER_27_378 VPWR VGND sg13g2_decap_8
XFILLER_42_315 VPWR VGND sg13g2_decap_8
XFILLER_10_223 VPWR VGND sg13g2_decap_8
XFILLER_23_584 VPWR VGND sg13g2_decap_8
XFILLER_24_99 VPWR VGND sg13g2_decap_8
XFILLER_40_21 VPWR VGND sg13g2_decap_8
XFILLER_2_466 VPWR VGND sg13g2_decap_8
XFILLER_40_98 VPWR VGND sg13g2_decap_8
XFILLER_18_323 VPWR VGND sg13g2_decap_8
XFILLER_46_665 VPWR VGND sg13g2_decap_8
XFILLER_49_74 VPWR VGND sg13g2_decap_8
XFILLER_14_573 VPWR VGND sg13g2_decap_8
XFILLER_41_392 VPWR VGND sg13g2_decap_8
XFILLER_45_175 VPWR VGND sg13g2_decap_8
X_0920_ net106 VGND VPWR _0080_ daisychain\[16\] clknet_5_5__leaf_clk sg13g2_dfrbpq_1
X_0851_ VPWR _0225_ daisychain\[32\] VGND sg13g2_inv_1
X_0782_ _0451_ net32 state\[62\] VPWR VGND sg13g2_nand2_1
XFILLER_28_109 VPWR VGND sg13g2_decap_8
XFILLER_24_337 VPWR VGND sg13g2_decap_8
XFILLER_36_153 VPWR VGND sg13g2_decap_8
Xinput3 ui_in[1] net3 VPWR VGND sg13g2_buf_1
XFILLER_20_554 VPWR VGND sg13g2_decap_8
XFILLER_10_13 VPWR VGND sg13g2_decap_8
XFILLER_19_77 VPWR VGND sg13g2_decap_8
XFILLER_43_602 VPWR VGND sg13g2_decap_8
XFILLER_11_521 VPWR VGND sg13g2_decap_8
XFILLER_23_381 VPWR VGND sg13g2_decap_8
XFILLER_27_175 VPWR VGND sg13g2_decap_8
XFILLER_35_32 VPWR VGND sg13g2_decap_8
XFILLER_42_112 VPWR VGND sg13g2_decap_8
XFILLER_42_189 VPWR VGND sg13g2_decap_8
XFILLER_7_525 VPWR VGND sg13g2_decap_8
XFILLER_2_263 VPWR VGND sg13g2_decap_8
XFILLER_18_120 VPWR VGND sg13g2_decap_8
XFILLER_18_197 VPWR VGND sg13g2_decap_8
XFILLER_19_665 VPWR VGND sg13g2_decap_8
XFILLER_46_462 VPWR VGND sg13g2_decap_8
X_1050_ daisychain\[58\] net17 VPWR VGND sg13g2_buf_1
XFILLER_14_370 VPWR VGND sg13g2_decap_8
XFILLER_33_167 VPWR VGND sg13g2_decap_8
X_0903_ VPWR _0251_ daisychain\[58\] VGND sg13g2_inv_1
X_0834_ VPWR _0048_ state\[24\] VGND sg13g2_inv_1
XFILLER_44_0 VPWR VGND sg13g2_decap_8
X_0765_ _0394_ VPWR _0173_ VGND net92 _0004_ sg13g2_o21ai_1
X_0696_ _0251_ net56 _0432_ _0433_ VPWR VGND sg13g2_a21o_1
XFILLER_6_580 VPWR VGND sg13g2_fill_1
XFILLER_37_440 VPWR VGND sg13g2_decap_8
Xclkbuf_5_25__f_clk clknet_5_25__leaf_clk clknet_4_12_0_clk VPWR VGND sg13g2_buf_16
XFILLER_12_307 VPWR VGND sg13g2_decap_8
XFILLER_24_134 VPWR VGND sg13g2_decap_8
XFILLER_40_649 VPWR VGND sg13g2_fill_2
XFILLER_20_351 VPWR VGND sg13g2_decap_8
XFILLER_21_78 VPWR VGND sg13g2_decap_8
XFILLER_0_712 VPWR VGND sg13g2_decap_4
XFILLER_28_473 VPWR VGND sg13g2_decap_8
XFILLER_46_42 VPWR VGND sg13g2_decap_8
XFILLER_47_259 VPWR VGND sg13g2_decap_8
XFILLER_48_749 VPWR VGND sg13g2_decap_8
XFILLER_11_340 VPWR VGND sg13g2_decap_8
XFILLER_15_167 VPWR VGND sg13g2_decap_8
XFILLER_30_137 VPWR VGND sg13g2_decap_8
XFILLER_31_627 VPWR VGND sg13g2_decap_8
XFILLER_43_476 VPWR VGND sg13g2_decap_8
XFILLER_7_322 VPWR VGND sg13g2_decap_8
XFILLER_7_14 VPWR VGND sg13g2_decap_8
XFILLER_3_550 VPWR VGND sg13g2_decap_4
XFILLER_3_561 VPWR VGND sg13g2_fill_2
XFILLER_3_572 VPWR VGND sg13g2_fill_2
X_0550_ _0085_ _0322_ _0323_ net40 _0214_ VPWR VGND sg13g2_a22oi_1
XFILLER_7_399 VPWR VGND sg13g2_decap_8
XFILLER_16_4 VPWR VGND sg13g2_fill_1
XFILLER_38_237 VPWR VGND sg13g2_decap_8
X_0481_ VGND VPWR net31 daisychain\[3\] _0272_ net35 sg13g2_a21oi_1
XFILLER_19_462 VPWR VGND sg13g2_decap_8
XFILLER_34_432 VPWR VGND sg13g2_decap_8
XFILLER_21_148 VPWR VGND sg13g2_decap_8
X_0817_ VPWR _0208_ daisychain\[15\] VGND sg13g2_inv_1
X_0748_ _0343_ VPWR _0156_ VGND net82 _0052_ sg13g2_o21ai_1
X_0679_ net89 VPWR _0420_ VGND net68 state\[54\] sg13g2_o21ai_1
XFILLER_25_421 VPWR VGND sg13g2_decap_8
XFILLER_29_237 VPWR VGND sg13g2_decap_8
XFILLER_12_104 VPWR VGND sg13g2_decap_8
XFILLER_16_78 VPWR VGND sg13g2_decap_8
XFILLER_25_498 VPWR VGND sg13g2_decap_8
XFILLER_32_11 VPWR VGND sg13g2_decap_8
XFILLER_32_22 VPWR VGND sg13g2_decap_8
XFILLER_40_413 VPWR VGND sg13g2_decap_8
XFILLER_32_99 VPWR VGND sg13g2_decap_8
XFILLER_4_347 VPWR VGND sg13g2_decap_8
XFILLER_0_553 VPWR VGND sg13g2_decap_8
XFILLER_48_546 VPWR VGND sg13g2_decap_8
XFILLER_16_421 VPWR VGND sg13g2_decap_8
XFILLER_16_498 VPWR VGND sg13g2_decap_8
XFILLER_28_270 VPWR VGND sg13g2_decap_8
XFILLER_29_771 VPWR VGND sg13g2_decap_8
XFILLER_31_424 VPWR VGND sg13g2_decap_8
XFILLER_35_207 VPWR VGND sg13g2_decap_8
XFILLER_43_273 VPWR VGND sg13g2_decap_8
XFILLER_44_774 VPWR VGND sg13g2_decap_8
XFILLER_44_785 VPWR VGND sg13g2_fill_1
XFILLER_12_682 VPWR VGND sg13g2_decap_8
X_0602_ _0098_ _0361_ _0362_ net46 _0227_ VPWR VGND sg13g2_a22oi_1
X_0533_ VGND VPWR net25 daisychain\[16\] _0311_ net40 sg13g2_a21oi_1
X_0464_ net76 net3 _0259_ VPWR VGND sg13g2_nor2_1
XFILLER_7_196 VPWR VGND sg13g2_decap_8
XFILLER_26_218 VPWR VGND sg13g2_decap_8
XFILLER_22_468 VPWR VGND sg13g2_decap_8
X_1016_ net116 VGND VPWR _0176_ state\[48\] clknet_5_28__leaf_clk sg13g2_dfrbpq_1
Xheichips25_pudding_120 VPWR VGND uio_oe[1] sg13g2_tiehi
XFILLER_8_90 VPWR VGND sg13g2_decap_8
XFILLER_13_413 VPWR VGND sg13g2_decap_8
XFILLER_27_77 VPWR VGND sg13g2_decap_8
XFILLER_40_210 VPWR VGND sg13g2_decap_8
XFILLER_41_733 VPWR VGND sg13g2_fill_1
XFILLER_43_21 VPWR VGND sg13g2_decap_8
XFILLER_25_295 VPWR VGND sg13g2_decap_8
XFILLER_40_287 VPWR VGND sg13g2_decap_8
XFILLER_43_98 VPWR VGND sg13g2_decap_8
XFILLER_9_417 VPWR VGND sg13g2_decap_8
XFILLER_5_678 VPWR VGND sg13g2_fill_1
XFILLER_4_144 VPWR VGND sg13g2_decap_8
XFILLER_0_350 VPWR VGND sg13g2_decap_8
XFILLER_17_730 VPWR VGND sg13g2_fill_1
XFILLER_48_343 VPWR VGND sg13g2_decap_8
XFILLER_16_295 VPWR VGND sg13g2_decap_8
XFILLER_31_221 VPWR VGND sg13g2_decap_8
XFILLER_44_560 VPWR VGND sg13g2_decap_8
XFILLER_31_298 VPWR VGND sg13g2_decap_8
XFILLER_8_461 VPWR VGND sg13g2_decap_8
XFILLER_39_343 VPWR VGND sg13g2_decap_8
X_0516_ _0206_ net61 _0297_ _0298_ VPWR VGND sg13g2_a21o_1
XFILLER_35_571 VPWR VGND sg13g2_decap_8
XFILLER_10_405 VPWR VGND sg13g2_decap_8
XFILLER_13_24 VPWR VGND sg13g2_decap_8
XFILLER_22_265 VPWR VGND sg13g2_decap_8
XFILLER_23_744 VPWR VGND sg13g2_decap_8
Xfanout25 net26 net25 VPWR VGND sg13g2_buf_1
Xfanout69 net73 net69 VPWR VGND sg13g2_buf_1
Xfanout58 net60 net58 VPWR VGND sg13g2_buf_1
Xfanout47 net53 net47 VPWR VGND sg13g2_buf_1
Xfanout36 net38 net36 VPWR VGND sg13g2_buf_1
XFILLER_1_147 VPWR VGND sg13g2_decap_8
XFILLER_2_637 VPWR VGND sg13g2_fill_1
XFILLER_2_659 VPWR VGND sg13g2_decap_8
XFILLER_18_505 VPWR VGND sg13g2_decap_8
XFILLER_38_21 VPWR VGND sg13g2_decap_8
XFILLER_38_76 VPWR VGND sg13g2_decap_8
XFILLER_13_276 VPWR VGND sg13g2_decap_8
XFILLER_26_582 VPWR VGND sg13g2_decap_8
XFILLER_41_574 VPWR VGND sg13g2_decap_8
XFILLER_45_357 VPWR VGND sg13g2_decap_8
XFILLER_9_214 VPWR VGND sg13g2_decap_8
Xdigitalen.g\[1\].u.inv2 VPWR digitalen.g\[1\].u.OUTP digitalen.g\[1\].u.OUTN VGND
+ sg13g2_inv_1
XFILLER_5_431 VPWR VGND sg13g2_decap_8
Xclkbuf_5_6__f_clk clknet_5_6__leaf_clk clknet_4_3_0_clk VPWR VGND sg13g2_buf_16
XFILLER_49_641 VPWR VGND sg13g2_decap_8
XFILLER_48_7 VPWR VGND sg13g2_decap_8
XFILLER_17_560 VPWR VGND sg13g2_decap_8
XFILLER_24_508 VPWR VGND sg13g2_decap_8
XFILLER_36_335 VPWR VGND sg13g2_decap_8
XFILLER_48_140 VPWR VGND sg13g2_decap_8
XFILLER_32_596 VPWR VGND sg13g2_decap_8
X_0996_ net104 VGND VPWR _0156_ state\[28\] clknet_5_14__leaf_clk sg13g2_dfrbpq_1
XFILLER_39_140 VPWR VGND sg13g2_decap_8
XFILLER_23_563 VPWR VGND sg13g2_decap_8
XFILLER_27_357 VPWR VGND sg13g2_decap_8
XFILLER_10_202 VPWR VGND sg13g2_decap_8
XFILLER_10_279 VPWR VGND sg13g2_decap_8
XFILLER_24_78 VPWR VGND sg13g2_decap_8
XFILLER_40_77 VPWR VGND sg13g2_decap_8
XFILLER_2_445 VPWR VGND sg13g2_decap_8
XFILLER_49_53 VPWR VGND sg13g2_decap_8
XFILLER_18_302 VPWR VGND sg13g2_decap_8
XFILLER_18_379 VPWR VGND sg13g2_decap_8
XFILLER_1_49 VPWR VGND sg13g2_decap_8
XFILLER_45_154 VPWR VGND sg13g2_decap_8
XFILLER_46_644 VPWR VGND sg13g2_decap_8
XFILLER_14_552 VPWR VGND sg13g2_decap_8
XFILLER_33_349 VPWR VGND sg13g2_decap_8
XFILLER_41_371 VPWR VGND sg13g2_decap_8
X_0850_ VPWR _0000_ state\[32\] VGND sg13g2_inv_1
X_0781_ _0442_ VPWR _0189_ VGND net76 _0021_ sg13g2_o21ai_1
Xinput4 ui_in[2] net4 VPWR VGND sg13g2_buf_1
XFILLER_24_316 VPWR VGND sg13g2_decap_8
XFILLER_36_132 VPWR VGND sg13g2_decap_8
XFILLER_20_533 VPWR VGND sg13g2_decap_8
XFILLER_32_393 VPWR VGND sg13g2_decap_8
X_0979_ net102 VGND VPWR _0139_ state\[11\] clknet_5_1__leaf_clk sg13g2_dfrbpq_1
XFILLER_10_69 VPWR VGND sg13g2_decap_8
XFILLER_19_56 VPWR VGND sg13g2_decap_8
XFILLER_27_154 VPWR VGND sg13g2_decap_8
XFILLER_28_655 VPWR VGND sg13g2_decap_4
XFILLER_11_500 VPWR VGND sg13g2_decap_8
XFILLER_15_349 VPWR VGND sg13g2_decap_8
XFILLER_23_360 VPWR VGND sg13g2_decap_8
XFILLER_30_319 VPWR VGND sg13g2_decap_8
XFILLER_35_88 VPWR VGND sg13g2_decap_8
XFILLER_42_168 VPWR VGND sg13g2_decap_8
XFILLER_7_504 VPWR VGND sg13g2_decap_8
XFILLER_11_577 VPWR VGND sg13g2_decap_8
XFILLER_2_242 VPWR VGND sg13g2_decap_8
XFILLER_38_419 VPWR VGND sg13g2_decap_8
XFILLER_3_798 VPWR VGND sg13g2_fill_1
XFILLER_18_176 VPWR VGND sg13g2_decap_8
XFILLER_19_644 VPWR VGND sg13g2_decap_8
XFILLER_33_146 VPWR VGND sg13g2_decap_8
XFILLER_34_614 VPWR VGND sg13g2_fill_2
XFILLER_46_441 VPWR VGND sg13g2_decap_8
X_0902_ VPWR _0018_ state\[58\] VGND sg13g2_inv_1
X_0833_ VPWR _0216_ daisychain\[23\] VGND sg13g2_inv_1
XFILLER_37_0 VPWR VGND sg13g2_decap_4
X_0764_ _0391_ VPWR _0172_ VGND net92 _0003_ sg13g2_o21ai_1
X_0695_ net77 VPWR _0432_ VGND net56 state\[58\] sg13g2_o21ai_1
XFILLER_25_603 VPWR VGND sg13g2_decap_8
XFILLER_29_419 VPWR VGND sg13g2_decap_8
XFILLER_2_81 VPWR VGND sg13g2_decap_8
XFILLER_20_330 VPWR VGND sg13g2_decap_8
XFILLER_24_113 VPWR VGND sg13g2_decap_8
XFILLER_25_669 VPWR VGND sg13g2_decap_8
XFILLER_32_190 VPWR VGND sg13g2_decap_8
XFILLER_40_617 VPWR VGND sg13g2_decap_4
XFILLER_21_57 VPWR VGND sg13g2_decap_8
XFILLER_4_529 VPWR VGND sg13g2_decap_8
XFILLER_0_735 VPWR VGND sg13g2_fill_2
XFILLER_48_728 VPWR VGND sg13g2_decap_8
XFILLER_15_146 VPWR VGND sg13g2_decap_8
XFILLER_16_603 VPWR VGND sg13g2_decap_8
XFILLER_28_452 VPWR VGND sg13g2_decap_8
XFILLER_31_606 VPWR VGND sg13g2_decap_8
XFILLER_43_455 VPWR VGND sg13g2_decap_8
XFILLER_46_21 VPWR VGND sg13g2_decap_8
XFILLER_46_98 VPWR VGND sg13g2_decap_8
XFILLER_47_238 VPWR VGND sg13g2_decap_8
XFILLER_11_396 VPWR VGND sg13g2_decap_8
XFILLER_30_116 VPWR VGND sg13g2_decap_8
XFILLER_31_639 VPWR VGND sg13g2_fill_2
XFILLER_7_301 VPWR VGND sg13g2_decap_8
Xclkbuf_5_31__f_clk clknet_5_31__leaf_clk clknet_4_15_0_clk VPWR VGND sg13g2_buf_16
X_0480_ _0197_ net57 _0270_ _0271_ VPWR VGND sg13g2_a21o_1
XFILLER_7_378 VPWR VGND sg13g2_decap_8
XFILLER_19_441 VPWR VGND sg13g2_decap_8
XFILLER_38_216 VPWR VGND sg13g2_decap_8
XFILLER_21_127 VPWR VGND sg13g2_decap_8
XFILLER_34_411 VPWR VGND sg13g2_decap_8
XFILLER_34_488 VPWR VGND sg13g2_decap_8
XFILLER_30_694 VPWR VGND sg13g2_fill_2
X_0816_ VPWR _0038_ state\[15\] VGND sg13g2_inv_1
X_0747_ _0340_ VPWR _0155_ VGND net81 _0051_ sg13g2_o21ai_1
XFILLER_29_216 VPWR VGND sg13g2_decap_8
X_0678_ _0117_ _0418_ _0419_ net50 _0246_ VPWR VGND sg13g2_a22oi_1
XFILLER_13_606 VPWR VGND sg13g2_fill_2
XFILLER_16_57 VPWR VGND sg13g2_decap_8
XFILLER_25_400 VPWR VGND sg13g2_decap_8
XFILLER_37_293 VPWR VGND sg13g2_decap_8
XFILLER_45_709 VPWR VGND sg13g2_fill_1
XFILLER_21_694 VPWR VGND sg13g2_decap_8
XFILLER_25_477 VPWR VGND sg13g2_decap_8
XFILLER_32_78 VPWR VGND sg13g2_decap_8
XFILLER_40_469 VPWR VGND sg13g2_decap_8
XFILLER_4_326 VPWR VGND sg13g2_decap_8
XFILLER_0_532 VPWR VGND sg13g2_decap_8
XFILLER_16_400 VPWR VGND sg13g2_decap_8
XFILLER_29_783 VPWR VGND sg13g2_decap_4
XFILLER_48_525 VPWR VGND sg13g2_decap_8
XFILLER_16_477 VPWR VGND sg13g2_decap_8
XFILLER_31_403 VPWR VGND sg13g2_decap_8
XFILLER_43_252 VPWR VGND sg13g2_decap_8
XFILLER_11_193 VPWR VGND sg13g2_decap_8
X_0601_ VGND VPWR net29 daisychain\[33\] _0362_ net46 sg13g2_a21oi_1
XFILLER_8_698 VPWR VGND sg13g2_fill_2
XFILLER_7_175 VPWR VGND sg13g2_decap_8
X_0532_ _0210_ net63 _0309_ _0310_ VPWR VGND sg13g2_a21o_1
X_0463_ net75 _0193_ _0257_ _0258_ VPWR VGND sg13g2_a21o_1
XFILLER_39_569 VPWR VGND sg13g2_decap_8
X_1015_ net117 VGND VPWR _0175_ state\[47\] clknet_5_17__leaf_clk sg13g2_dfrbpq_1
Xheichips25_pudding_121 VPWR VGND uio_oe[2] sg13g2_tiehi
XFILLER_22_447 VPWR VGND sg13g2_decap_8
XFILLER_30_480 VPWR VGND sg13g2_decap_8
XFILLER_34_285 VPWR VGND sg13g2_decap_8
XFILLER_1_329 VPWR VGND sg13g2_decap_8
XFILLER_25_274 VPWR VGND sg13g2_decap_8
XFILLER_27_56 VPWR VGND sg13g2_decap_8
XFILLER_45_539 VPWR VGND sg13g2_decap_8
XFILLER_13_469 VPWR VGND sg13g2_decap_8
XFILLER_21_491 VPWR VGND sg13g2_decap_8
XFILLER_40_266 VPWR VGND sg13g2_decap_8
XFILLER_43_77 VPWR VGND sg13g2_decap_8
XFILLER_5_624 VPWR VGND sg13g2_decap_8
XFILLER_4_123 VPWR VGND sg13g2_decap_8
XFILLER_5_668 VPWR VGND sg13g2_fill_1
XFILLER_29_580 VPWR VGND sg13g2_decap_8
XFILLER_36_517 VPWR VGND sg13g2_decap_8
XFILLER_48_399 VPWR VGND sg13g2_decap_8
XFILLER_48_322 VPWR VGND sg13g2_decap_8
XFILLER_12_480 VPWR VGND sg13g2_decap_8
XFILLER_16_274 VPWR VGND sg13g2_decap_8
XFILLER_17_797 VPWR VGND sg13g2_decap_8
XFILLER_31_200 VPWR VGND sg13g2_decap_8
XFILLER_31_277 VPWR VGND sg13g2_decap_8
XFILLER_8_440 VPWR VGND sg13g2_decap_8
XFILLER_39_322 VPWR VGND sg13g2_decap_8
X_0515_ net83 VPWR _0297_ VGND net61 state\[13\] sg13g2_o21ai_1
XFILLER_27_539 VPWR VGND sg13g2_decap_8
XFILLER_35_550 VPWR VGND sg13g2_decap_8
XFILLER_39_399 VPWR VGND sg13g2_decap_8
Xfanout26 net30 net26 VPWR VGND sg13g2_buf_1
Xfanout37 net38 net37 VPWR VGND sg13g2_buf_1
XFILLER_22_244 VPWR VGND sg13g2_decap_8
Xfanout59 net60 net59 VPWR VGND sg13g2_buf_1
Xfanout48 net52 net48 VPWR VGND sg13g2_buf_1
XFILLER_1_126 VPWR VGND sg13g2_decap_8
XFILLER_45_336 VPWR VGND sg13g2_decap_8
XFILLER_13_255 VPWR VGND sg13g2_decap_8
XFILLER_26_561 VPWR VGND sg13g2_decap_8
XFILLER_41_553 VPWR VGND sg13g2_decap_8
XFILLER_5_487 VPWR VGND sg13g2_decap_8
XFILLER_5_410 VPWR VGND sg13g2_decap_8
XFILLER_49_620 VPWR VGND sg13g2_decap_8
XFILLER_36_314 VPWR VGND sg13g2_decap_8
XFILLER_48_196 VPWR VGND sg13g2_decap_8
XFILLER_49_697 VPWR VGND sg13g2_decap_8
XFILLER_32_575 VPWR VGND sg13g2_decap_8
X_0995_ net104 VGND VPWR _0155_ state\[27\] clknet_5_14__leaf_clk sg13g2_dfrbpq_1
XFILLER_5_81 VPWR VGND sg13g2_decap_8
XFILLER_27_336 VPWR VGND sg13g2_decap_8
XFILLER_28_804 VPWR VGND sg13g2_decap_8
XFILLER_39_196 VPWR VGND sg13g2_decap_8
XFILLER_23_542 VPWR VGND sg13g2_decap_8
XFILLER_24_57 VPWR VGND sg13g2_decap_8
XFILLER_10_258 VPWR VGND sg13g2_decap_8
XFILLER_40_56 VPWR VGND sg13g2_decap_8
XFILLER_6_229 VPWR VGND sg13g2_decap_8
XFILLER_1_28 VPWR VGND sg13g2_decap_8
XFILLER_2_424 VPWR VGND sg13g2_decap_8
XFILLER_6_4 VPWR VGND sg13g2_decap_8
XFILLER_49_32 VPWR VGND sg13g2_decap_8
XFILLER_14_531 VPWR VGND sg13g2_decap_8
XFILLER_18_358 VPWR VGND sg13g2_decap_8
XFILLER_33_328 VPWR VGND sg13g2_decap_8
XFILLER_45_133 VPWR VGND sg13g2_decap_8
XFILLER_46_623 VPWR VGND sg13g2_decap_8
XFILLER_14_90 VPWR VGND sg13g2_decap_8
XFILLER_41_350 VPWR VGND sg13g2_decap_8
X_0780_ _0439_ VPWR _0188_ VGND net88 _0020_ sg13g2_o21ai_1
XFILLER_5_284 VPWR VGND sg13g2_decap_8
XFILLER_1_490 VPWR VGND sg13g2_decap_8
XFILLER_25_807 VPWR VGND sg13g2_decap_8
XFILLER_36_111 VPWR VGND sg13g2_decap_8
Xinput5 ui_in[3] net5 VPWR VGND sg13g2_buf_1
XFILLER_49_494 VPWR VGND sg13g2_decap_8
XFILLER_20_512 VPWR VGND sg13g2_decap_8
XFILLER_32_372 VPWR VGND sg13g2_decap_8
XFILLER_36_188 VPWR VGND sg13g2_decap_8
XFILLER_20_589 VPWR VGND sg13g2_decap_8
X_0978_ net105 VGND VPWR _0138_ state\[10\] clknet_5_3__leaf_clk sg13g2_dfrbpq_1
XFILLER_10_48 VPWR VGND sg13g2_decap_8
XFILLER_19_13 VPWR VGND sg13g2_fill_2
XFILLER_19_35 VPWR VGND sg13g2_decap_8
XFILLER_15_328 VPWR VGND sg13g2_decap_8
XFILLER_27_133 VPWR VGND sg13g2_decap_8
XFILLER_28_634 VPWR VGND sg13g2_decap_8
XFILLER_35_67 VPWR VGND sg13g2_decap_8
XFILLER_43_637 VPWR VGND sg13g2_decap_8
XFILLER_43_659 VPWR VGND sg13g2_decap_8
XFILLER_11_556 VPWR VGND sg13g2_decap_8
XFILLER_42_147 VPWR VGND sg13g2_decap_8
XFILLER_2_221 VPWR VGND sg13g2_decap_8
XFILLER_19_623 VPWR VGND sg13g2_decap_8
XFILLER_2_298 VPWR VGND sg13g2_decap_8
XFILLER_46_420 VPWR VGND sg13g2_decap_8
XFILLER_18_155 VPWR VGND sg13g2_decap_8
XFILLER_21_309 VPWR VGND sg13g2_decap_8
XFILLER_30_810 VPWR VGND sg13g2_decap_8
XFILLER_30_821 VPWR VGND sg13g2_fill_2
XFILLER_33_125 VPWR VGND sg13g2_decap_8
XFILLER_46_497 VPWR VGND sg13g2_decap_8
X_0901_ VPWR _0250_ daisychain\[57\] VGND sg13g2_inv_1
X_0832_ VPWR _0047_ state\[23\] VGND sg13g2_inv_1
X_0763_ _0388_ VPWR _0171_ VGND net91 _0002_ sg13g2_o21ai_1
X_0694_ _0121_ _0430_ _0431_ net33 _0250_ VPWR VGND sg13g2_a22oi_1
XFILLER_25_648 VPWR VGND sg13g2_decap_8
XFILLER_2_60 VPWR VGND sg13g2_decap_8
XFILLER_37_497 VPWR VGND sg13g2_decap_8
XFILLER_49_291 VPWR VGND sg13g2_decap_8
XFILLER_21_821 VPWR VGND sg13g2_fill_2
XFILLER_24_169 VPWR VGND sg13g2_decap_8
XFILLER_20_386 VPWR VGND sg13g2_decap_8
XFILLER_21_36 VPWR VGND sg13g2_decap_8
XFILLER_4_508 VPWR VGND sg13g2_decap_8
XFILLER_28_431 VPWR VGND sg13g2_decap_8
XFILLER_47_217 VPWR VGND sg13g2_decap_8
XFILLER_48_707 VPWR VGND sg13g2_decap_8
XFILLER_15_125 VPWR VGND sg13g2_decap_8
XFILLER_43_434 VPWR VGND sg13g2_decap_8
XFILLER_46_77 VPWR VGND sg13g2_decap_8
XFILLER_11_375 VPWR VGND sg13g2_decap_8
XFILLER_7_49 VPWR VGND sg13g2_decap_8
XFILLER_7_357 VPWR VGND sg13g2_decap_8
XFILLER_30_8 VPWR VGND sg13g2_fill_2
Xclkbuf_4_9_0_clk clknet_0_clk clknet_4_9_0_clk VPWR VGND sg13g2_buf_8
XFILLER_19_420 VPWR VGND sg13g2_decap_8
XFILLER_19_497 VPWR VGND sg13g2_decap_8
XFILLER_39_729 VPWR VGND sg13g2_decap_8
XFILLER_46_294 VPWR VGND sg13g2_decap_8
XFILLER_47_751 VPWR VGND sg13g2_fill_1
XFILLER_47_784 VPWR VGND sg13g2_decap_8
X_1031_ net98 VGND VPWR _0191_ state\[63\] clknet_5_11__leaf_clk sg13g2_dfrbpq_1
XFILLER_15_670 VPWR VGND sg13g2_decap_8
XFILLER_21_106 VPWR VGND sg13g2_decap_8
XFILLER_22_629 VPWR VGND sg13g2_decap_8
XFILLER_30_673 VPWR VGND sg13g2_decap_8
XFILLER_34_467 VPWR VGND sg13g2_decap_8
X_0815_ VPWR _0207_ daisychain\[14\] VGND sg13g2_inv_1
X_0746_ _0337_ VPWR _0154_ VGND net81 _0050_ sg13g2_o21ai_1
XFILLER_6_390 VPWR VGND sg13g2_decap_8
X_0677_ VGND VPWR net30 daisychain\[52\] _0419_ net50 sg13g2_a21oi_1
XFILLER_16_36 VPWR VGND sg13g2_decap_8
XFILLER_25_456 VPWR VGND sg13g2_decap_8
XFILLER_37_272 VPWR VGND sg13g2_decap_8
XFILLER_12_139 VPWR VGND sg13g2_decap_8
XFILLER_20_183 VPWR VGND sg13g2_decap_8
XFILLER_21_673 VPWR VGND sg13g2_decap_8
XFILLER_32_57 VPWR VGND sg13g2_decap_8
XFILLER_40_448 VPWR VGND sg13g2_decap_8
XFILLER_4_305 VPWR VGND sg13g2_decap_8
XFILLER_0_511 VPWR VGND sg13g2_decap_8
XFILLER_0_588 VPWR VGND sg13g2_decap_4
XFILLER_0_599 VPWR VGND sg13g2_decap_8
XFILLER_48_504 VPWR VGND sg13g2_decap_8
XFILLER_16_456 VPWR VGND sg13g2_decap_8
XFILLER_31_459 VPWR VGND sg13g2_decap_8
XFILLER_43_231 VPWR VGND sg13g2_decap_8
XFILLER_11_172 VPWR VGND sg13g2_decap_8
XFILLER_22_90 VPWR VGND sg13g2_decap_8
X_0600_ _0227_ net67 _0360_ _0361_ VPWR VGND sg13g2_a21o_1
X_0531_ net85 VPWR _0309_ VGND net63 state\[17\] sg13g2_o21ai_1
XFILLER_7_154 VPWR VGND sg13g2_decap_8
XFILLER_39_548 VPWR VGND sg13g2_decap_8
XFILLER_3_382 VPWR VGND sg13g2_decap_8
X_0462_ net79 VPWR _0257_ VGND state\[0\] net57 sg13g2_o21ai_1
XFILLER_19_294 VPWR VGND sg13g2_decap_8
XFILLER_22_426 VPWR VGND sg13g2_decap_8
XFILLER_34_264 VPWR VGND sg13g2_decap_8
XFILLER_47_581 VPWR VGND sg13g2_decap_8
X_1014_ net113 VGND VPWR _0174_ state\[46\] clknet_5_16__leaf_clk sg13g2_dfrbpq_1
Xheichips25_pudding_122 VPWR VGND uio_oe[3] sg13g2_tiehi
XFILLER_1_308 VPWR VGND sg13g2_decap_8
X_0729_ _0286_ VPWR _0137_ VGND net84 _0063_ sg13g2_o21ai_1
XFILLER_27_35 VPWR VGND sg13g2_decap_8
XFILLER_38_581 VPWR VGND sg13g2_decap_8
XFILLER_45_518 VPWR VGND sg13g2_decap_8
XFILLER_13_448 VPWR VGND sg13g2_decap_8
XFILLER_25_253 VPWR VGND sg13g2_decap_8
XFILLER_40_245 VPWR VGND sg13g2_decap_8
XFILLER_43_56 VPWR VGND sg13g2_decap_8
XFILLER_21_470 VPWR VGND sg13g2_decap_8
XFILLER_5_647 VPWR VGND sg13g2_fill_2
XFILLER_5_603 VPWR VGND sg13g2_decap_8
XFILLER_4_102 VPWR VGND sg13g2_decap_8
XFILLER_0_385 VPWR VGND sg13g2_decap_8
XFILLER_4_39 VPWR VGND sg13g2_decap_8
XFILLER_4_179 VPWR VGND sg13g2_decap_8
XFILLER_49_802 VPWR VGND sg13g2_decap_8
XFILLER_48_301 VPWR VGND sg13g2_decap_8
XFILLER_16_253 VPWR VGND sg13g2_decap_8
XFILLER_17_765 VPWR VGND sg13g2_fill_2
XFILLER_48_378 VPWR VGND sg13g2_decap_8
XFILLER_31_256 VPWR VGND sg13g2_decap_8
XFILLER_44_595 VPWR VGND sg13g2_decap_8
X_0514_ _0076_ _0295_ _0296_ net39 _0205_ VPWR VGND sg13g2_a22oi_1
XFILLER_8_496 VPWR VGND sg13g2_decap_8
XFILLER_27_518 VPWR VGND sg13g2_decap_8
XFILLER_39_301 VPWR VGND sg13g2_decap_8
XFILLER_39_378 VPWR VGND sg13g2_decap_8
XFILLER_22_223 VPWR VGND sg13g2_decap_8
Xfanout27 net28 net27 VPWR VGND sg13g2_buf_1
Xfanout49 net52 net49 VPWR VGND sg13g2_buf_1
Xfanout38 net44 net38 VPWR VGND sg13g2_buf_1
XFILLER_13_59 VPWR VGND sg13g2_decap_8
XFILLER_2_606 VPWR VGND sg13g2_fill_1
XFILLER_1_105 VPWR VGND sg13g2_decap_8
XFILLER_8_8 VPWR VGND sg13g2_fill_1
XFILLER_49_109 VPWR VGND sg13g2_decap_8
XFILLER_26_540 VPWR VGND sg13g2_decap_8
XFILLER_45_315 VPWR VGND sg13g2_decap_8
XFILLER_13_234 VPWR VGND sg13g2_decap_8
XFILLER_41_532 VPWR VGND sg13g2_decap_8
XFILLER_9_249 VPWR VGND sg13g2_decap_8
XFILLER_5_466 VPWR VGND sg13g2_decap_8
XFILLER_0_182 VPWR VGND sg13g2_decap_8
XFILLER_48_175 VPWR VGND sg13g2_decap_8
XFILLER_49_676 VPWR VGND sg13g2_decap_8
XFILLER_17_595 VPWR VGND sg13g2_decap_8
XFILLER_32_554 VPWR VGND sg13g2_decap_8
XFILLER_44_392 VPWR VGND sg13g2_decap_8
X_0994_ net103 VGND VPWR _0154_ state\[26\] clknet_5_9__leaf_clk sg13g2_dfrbpq_1
XFILLER_8_293 VPWR VGND sg13g2_decap_8
XFILLER_5_60 VPWR VGND sg13g2_decap_8
XFILLER_27_315 VPWR VGND sg13g2_decap_8
XFILLER_39_175 VPWR VGND sg13g2_decap_8
XFILLER_10_237 VPWR VGND sg13g2_decap_8
XFILLER_23_521 VPWR VGND sg13g2_decap_8
XFILLER_23_598 VPWR VGND sg13g2_decap_8
XFILLER_24_36 VPWR VGND sg13g2_decap_8
XFILLER_42_329 VPWR VGND sg13g2_decap_8
XFILLER_6_208 VPWR VGND sg13g2_decap_8
XFILLER_2_403 VPWR VGND sg13g2_decap_8
XFILLER_40_35 VPWR VGND sg13g2_decap_8
XFILLER_49_11 VPWR VGND sg13g2_decap_8
XFILLER_46_602 VPWR VGND sg13g2_decap_8
XFILLER_49_88 VPWR VGND sg13g2_decap_8
XFILLER_14_510 VPWR VGND sg13g2_decap_8
XFILLER_18_337 VPWR VGND sg13g2_decap_8
XFILLER_33_307 VPWR VGND sg13g2_decap_8
XFILLER_45_112 VPWR VGND sg13g2_decap_8
XFILLER_45_189 VPWR VGND sg13g2_decap_8
XFILLER_46_679 VPWR VGND sg13g2_decap_8
XFILLER_14_587 VPWR VGND sg13g2_decap_8
XFILLER_6_742 VPWR VGND sg13g2_fill_2
Xclkbuf_5_14__f_clk clknet_5_14__leaf_clk clknet_4_7_0_clk VPWR VGND sg13g2_buf_16
Xwires dac0/VcascP[0] dac0/VcascP[1] dac0/Iout wires/VDDA[0] wires/VDDA[1] dac0/VbiasP[1]
+ dac0/VbiasP[0] dac1/VcascP[0] dac1/VcascP[1] dac1/Iout wires/VDDA[2] wires/VDDA[3]
+ dac1/VbiasP[1] dac1/VbiasP[0] i_in i_out analog_wires
XFILLER_5_263 VPWR VGND sg13g2_decap_8
XFILLER_36_167 VPWR VGND sg13g2_decap_8
Xinput6 ui_in[4] net6 VPWR VGND sg13g2_buf_1
XFILLER_49_473 VPWR VGND sg13g2_decap_8
XFILLER_17_392 VPWR VGND sg13g2_decap_8
XFILLER_32_351 VPWR VGND sg13g2_decap_8
XFILLER_10_27 VPWR VGND sg13g2_decap_8
XFILLER_20_568 VPWR VGND sg13g2_decap_8
X_0977_ net105 VGND VPWR _0137_ state\[9\] clknet_5_1__leaf_clk sg13g2_dfrbpq_1
XFILLER_28_613 VPWR VGND sg13g2_decap_8
XFILLER_15_307 VPWR VGND sg13g2_decap_8
XFILLER_27_112 VPWR VGND sg13g2_decap_8
XFILLER_27_189 VPWR VGND sg13g2_decap_8
XFILLER_35_13 VPWR VGND sg13g2_fill_1
XFILLER_35_46 VPWR VGND sg13g2_decap_8
XFILLER_42_126 VPWR VGND sg13g2_decap_8
XFILLER_43_616 VPWR VGND sg13g2_decap_8
XFILLER_11_535 VPWR VGND sg13g2_decap_8
XFILLER_23_395 VPWR VGND sg13g2_decap_8
XFILLER_7_539 VPWR VGND sg13g2_decap_8
XFILLER_2_200 VPWR VGND sg13g2_decap_8
XFILLER_2_277 VPWR VGND sg13g2_decap_8
XFILLER_3_789 VPWR VGND sg13g2_decap_8
XFILLER_18_134 VPWR VGND sg13g2_decap_8
XFILLER_19_602 VPWR VGND sg13g2_decap_8
XFILLER_19_679 VPWR VGND sg13g2_fill_2
XFILLER_46_476 VPWR VGND sg13g2_decap_8
XFILLER_14_384 VPWR VGND sg13g2_decap_8
XFILLER_33_104 VPWR VGND sg13g2_decap_8
X_0900_ VPWR _0017_ state\[57\] VGND sg13g2_inv_1
X_0831_ VPWR _0215_ daisychain\[22\] VGND sg13g2_inv_1
X_0762_ _0385_ VPWR _0170_ VGND net91 _0001_ sg13g2_o21ai_1
X_0693_ VGND VPWR net32 daisychain\[56\] _0431_ net33 sg13g2_a21oi_1
XFILLER_24_148 VPWR VGND sg13g2_decap_8
XFILLER_37_454 VPWR VGND sg13g2_decap_8
XFILLER_49_270 VPWR VGND sg13g2_decap_8
XFILLER_20_365 VPWR VGND sg13g2_decap_8
XFILLER_0_748 VPWR VGND sg13g2_fill_1
XFILLER_28_410 VPWR VGND sg13g2_decap_8
XFILLER_46_56 VPWR VGND sg13g2_decap_8
XFILLER_15_104 VPWR VGND sg13g2_decap_8
XFILLER_16_627 VPWR VGND sg13g2_decap_8
XFILLER_23_192 VPWR VGND sg13g2_decap_8
XFILLER_28_487 VPWR VGND sg13g2_decap_8
XFILLER_43_413 VPWR VGND sg13g2_decap_8
XFILLER_11_354 VPWR VGND sg13g2_decap_8
XFILLER_7_336 VPWR VGND sg13g2_decap_8
XFILLER_7_28 VPWR VGND sg13g2_decap_8
XFILLER_11_81 VPWR VGND sg13g2_decap_8
XFILLER_39_719 VPWR VGND sg13g2_fill_1
XFILLER_3_586 VPWR VGND sg13g2_fill_1
XFILLER_3_597 VPWR VGND sg13g2_fill_2
XFILLER_19_476 VPWR VGND sg13g2_decap_8
XFILLER_22_608 VPWR VGND sg13g2_decap_8
XFILLER_34_446 VPWR VGND sg13g2_decap_8
XFILLER_46_273 VPWR VGND sg13g2_decap_8
X_1030_ net98 VGND VPWR _0190_ state\[62\] clknet_5_11__leaf_clk sg13g2_dfrbpq_1
XFILLER_14_181 VPWR VGND sg13g2_decap_8
XFILLER_42_490 VPWR VGND sg13g2_decap_8
X_0814_ VPWR _0037_ state\[14\] VGND sg13g2_inv_1
XFILLER_42_0 VPWR VGND sg13g2_decap_8
X_0745_ _0334_ VPWR _0153_ VGND net81 _0049_ sg13g2_o21ai_1
X_0676_ _0246_ net72 _0417_ _0418_ VPWR VGND sg13g2_a21o_1
XFILLER_37_251 VPWR VGND sg13g2_decap_8
XFILLER_12_118 VPWR VGND sg13g2_decap_8
XFILLER_25_435 VPWR VGND sg13g2_decap_8
XFILLER_40_427 VPWR VGND sg13g2_decap_8
XFILLER_20_162 VPWR VGND sg13g2_decap_8
XFILLER_21_652 VPWR VGND sg13g2_decap_8
XFILLER_32_36 VPWR VGND sg13g2_decap_8
XFILLER_0_567 VPWR VGND sg13g2_decap_8
XFILLER_16_435 VPWR VGND sg13g2_decap_8
XFILLER_28_284 VPWR VGND sg13g2_decap_8
XFILLER_43_210 VPWR VGND sg13g2_decap_8
XFILLER_11_151 VPWR VGND sg13g2_decap_8
XFILLER_12_696 VPWR VGND sg13g2_fill_1
XFILLER_31_438 VPWR VGND sg13g2_decap_8
XFILLER_43_287 VPWR VGND sg13g2_decap_8
XFILLER_44_799 VPWR VGND sg13g2_fill_2
XFILLER_8_656 VPWR VGND sg13g2_fill_1
XFILLER_3_361 VPWR VGND sg13g2_decap_8
X_0530_ _0080_ _0307_ _0308_ net40 _0209_ VPWR VGND sg13g2_a22oi_1
XFILLER_7_133 VPWR VGND sg13g2_decap_8
XFILLER_14_4 VPWR VGND sg13g2_fill_2
X_0461_ VPWR _0256_ daisychain\[63\] VGND sg13g2_inv_1
XFILLER_19_273 VPWR VGND sg13g2_decap_8
XFILLER_22_405 VPWR VGND sg13g2_decap_8
XFILLER_34_243 VPWR VGND sg13g2_decap_8
XFILLER_47_560 VPWR VGND sg13g2_decap_8
X_1013_ net113 VGND VPWR _0173_ state\[45\] clknet_5_17__leaf_clk sg13g2_dfrbpq_1
Xheichips25_pudding_123 VPWR VGND uio_oe[4] sg13g2_tiehi
X_0728_ _0283_ VPWR _0136_ VGND net80 _0062_ sg13g2_o21ai_1
X_0659_ net94 VPWR _0405_ VGND net72 state\[49\] sg13g2_o21ai_1
XFILLER_25_232 VPWR VGND sg13g2_decap_8
XFILLER_27_14 VPWR VGND sg13g2_decap_8
XFILLER_13_427 VPWR VGND sg13g2_decap_8
XFILLER_40_224 VPWR VGND sg13g2_decap_8
XFILLER_43_35 VPWR VGND sg13g2_decap_8
Xclkbuf_4_8_0_clk clknet_0_clk clknet_4_8_0_clk VPWR VGND sg13g2_buf_8
XFILLER_4_18 VPWR VGND sg13g2_decap_8
XFILLER_4_158 VPWR VGND sg13g2_decap_8
XFILLER_0_364 VPWR VGND sg13g2_decap_8
XFILLER_1_821 VPWR VGND sg13g2_fill_2
XFILLER_48_357 VPWR VGND sg13g2_decap_8
XFILLER_16_232 VPWR VGND sg13g2_decap_8
XFILLER_17_91 VPWR VGND sg13g2_decap_8
XFILLER_31_235 VPWR VGND sg13g2_decap_8
XFILLER_44_574 VPWR VGND sg13g2_decap_8
XFILLER_33_90 VPWR VGND sg13g2_decap_8
XFILLER_8_475 VPWR VGND sg13g2_decap_8
X_0513_ VGND VPWR net23 daisychain\[11\] _0296_ net36 sg13g2_a21oi_1
XFILLER_39_357 VPWR VGND sg13g2_decap_8
XFILLER_10_419 VPWR VGND sg13g2_decap_8
XFILLER_13_38 VPWR VGND sg13g2_decap_8
XFILLER_22_202 VPWR VGND sg13g2_decap_8
XFILLER_22_279 VPWR VGND sg13g2_decap_8
XFILLER_35_585 VPWR VGND sg13g2_decap_8
Xfanout28 net30 net28 VPWR VGND sg13g2_buf_1
Xfanout39 net43 net39 VPWR VGND sg13g2_buf_1
XFILLER_38_35 VPWR VGND sg13g2_decap_8
XFILLER_38_46 VPWR VGND sg13g2_fill_1
XFILLER_13_213 VPWR VGND sg13g2_decap_8
XFILLER_18_519 VPWR VGND sg13g2_decap_8
XFILLER_26_596 VPWR VGND sg13g2_decap_8
XFILLER_41_511 VPWR VGND sg13g2_decap_8
XFILLER_41_588 VPWR VGND sg13g2_decap_8
XFILLER_9_228 VPWR VGND sg13g2_decap_8
XFILLER_5_445 VPWR VGND sg13g2_decap_8
XFILLER_0_161 VPWR VGND sg13g2_decap_8
XFILLER_36_349 VPWR VGND sg13g2_decap_8
XFILLER_48_154 VPWR VGND sg13g2_decap_8
XFILLER_49_655 VPWR VGND sg13g2_decap_8
XFILLER_17_574 VPWR VGND sg13g2_decap_8
XFILLER_32_533 VPWR VGND sg13g2_decap_8
XFILLER_44_371 VPWR VGND sg13g2_decap_8
X_0993_ net103 VGND VPWR _0153_ state\[25\] clknet_5_15__leaf_clk sg13g2_dfrbpq_1
XFILLER_8_272 VPWR VGND sg13g2_decap_8
XFILLER_23_500 VPWR VGND sg13g2_decap_8
XFILLER_35_382 VPWR VGND sg13g2_decap_8
XFILLER_39_154 VPWR VGND sg13g2_decap_8
XFILLER_42_308 VPWR VGND sg13g2_decap_8
XFILLER_10_216 VPWR VGND sg13g2_decap_8
XFILLER_23_577 VPWR VGND sg13g2_decap_8
XFILLER_40_14 VPWR VGND sg13g2_decap_8
XFILLER_2_459 VPWR VGND sg13g2_decap_8
XFILLER_18_316 VPWR VGND sg13g2_decap_8
XFILLER_46_658 VPWR VGND sg13g2_decap_8
XFILLER_49_67 VPWR VGND sg13g2_decap_8
XFILLER_14_566 VPWR VGND sg13g2_decap_8
XFILLER_26_393 VPWR VGND sg13g2_decap_8
XFILLER_41_385 VPWR VGND sg13g2_decap_8
XFILLER_45_168 VPWR VGND sg13g2_decap_8
XFILLER_5_242 VPWR VGND sg13g2_decap_8
XFILLER_46_7 VPWR VGND sg13g2_decap_8
XFILLER_17_371 VPWR VGND sg13g2_decap_8
XFILLER_36_146 VPWR VGND sg13g2_decap_8
XFILLER_37_647 VPWR VGND sg13g2_fill_1
XFILLER_49_452 VPWR VGND sg13g2_decap_8
XFILLER_20_547 VPWR VGND sg13g2_decap_8
XFILLER_32_330 VPWR VGND sg13g2_decap_8
X_0976_ net102 VGND VPWR _0136_ state\[8\] clknet_5_13__leaf_clk sg13g2_dfrbpq_1
XFILLER_19_15 VPWR VGND sg13g2_fill_1
XFILLER_11_514 VPWR VGND sg13g2_decap_8
XFILLER_23_374 VPWR VGND sg13g2_decap_8
XFILLER_27_168 VPWR VGND sg13g2_decap_8
XFILLER_42_105 VPWR VGND sg13g2_decap_8
Xclkbuf_5_20__f_clk clknet_5_20__leaf_clk clknet_4_10_0_clk VPWR VGND sg13g2_buf_16
XFILLER_7_518 VPWR VGND sg13g2_decap_8
XFILLER_2_256 VPWR VGND sg13g2_decap_8
XFILLER_18_113 VPWR VGND sg13g2_decap_8
XFILLER_19_658 VPWR VGND sg13g2_decap_8
XFILLER_46_455 VPWR VGND sg13g2_decap_8
XFILLER_14_363 VPWR VGND sg13g2_decap_8
XFILLER_26_190 VPWR VGND sg13g2_decap_8
XFILLER_27_691 VPWR VGND sg13g2_decap_8
XFILLER_41_182 VPWR VGND sg13g2_decap_8
X_0830_ VPWR _0046_ state\[22\] VGND sg13g2_inv_1
X_0761_ _0382_ VPWR _0169_ VGND net91 _0031_ sg13g2_o21ai_1
X_0692_ _0250_ net55 _0429_ _0430_ VPWR VGND sg13g2_a21o_1
XFILLER_2_95 VPWR VGND sg13g2_decap_8
XFILLER_37_433 VPWR VGND sg13g2_decap_8
XFILLER_24_127 VPWR VGND sg13g2_decap_8
XFILLER_25_617 VPWR VGND sg13g2_decap_4
XFILLER_20_344 VPWR VGND sg13g2_decap_8
X_0959_ net110 VGND VPWR _0119_ daisychain\[55\] clknet_5_26__leaf_clk sg13g2_dfrbpq_1
XFILLER_0_716 VPWR VGND sg13g2_fill_1
XFILLER_16_617 VPWR VGND sg13g2_decap_4
XFILLER_28_466 VPWR VGND sg13g2_decap_8
XFILLER_46_35 VPWR VGND sg13g2_decap_8
XFILLER_11_333 VPWR VGND sg13g2_decap_8
XFILLER_23_171 VPWR VGND sg13g2_decap_8
XFILLER_24_683 VPWR VGND sg13g2_decap_4
XFILLER_43_469 VPWR VGND sg13g2_decap_8
XFILLER_7_315 VPWR VGND sg13g2_decap_8
XFILLER_11_60 VPWR VGND sg13g2_decap_8
XFILLER_3_543 VPWR VGND sg13g2_decap_8
XFILLER_39_709 VPWR VGND sg13g2_fill_2
XFILLER_19_455 VPWR VGND sg13g2_decap_8
XFILLER_34_425 VPWR VGND sg13g2_decap_8
XFILLER_36_90 VPWR VGND sg13g2_decap_8
XFILLER_46_252 VPWR VGND sg13g2_decap_8
XFILLER_14_160 VPWR VGND sg13g2_decap_8
XFILLER_30_620 VPWR VGND sg13g2_decap_8
XFILLER_30_664 VPWR VGND sg13g2_fill_2
X_0813_ VPWR _0206_ daisychain\[13\] VGND sg13g2_inv_1
XFILLER_35_0 VPWR VGND sg13g2_decap_8
X_0744_ _0331_ VPWR _0152_ VGND net80 _0048_ sg13g2_o21ai_1
X_0675_ net93 VPWR _0417_ VGND net72 state\[53\] sg13g2_o21ai_1
XFILLER_25_414 VPWR VGND sg13g2_decap_8
XFILLER_37_230 VPWR VGND sg13g2_decap_8
XFILLER_20_141 VPWR VGND sg13g2_decap_8
XFILLER_21_631 VPWR VGND sg13g2_decap_8
XFILLER_40_406 VPWR VGND sg13g2_decap_8
XFILLER_0_546 VPWR VGND sg13g2_decap_8
XFILLER_48_539 VPWR VGND sg13g2_decap_8
XFILLER_16_414 VPWR VGND sg13g2_decap_8
XFILLER_28_263 VPWR VGND sg13g2_decap_8
XFILLER_29_742 VPWR VGND sg13g2_fill_2
XFILLER_29_764 VPWR VGND sg13g2_decap_8
XFILLER_31_417 VPWR VGND sg13g2_decap_8
XFILLER_43_266 VPWR VGND sg13g2_decap_8
XFILLER_44_767 VPWR VGND sg13g2_decap_8
XFILLER_44_789 VPWR VGND sg13g2_fill_1
XFILLER_11_130 VPWR VGND sg13g2_decap_8
XFILLER_12_631 VPWR VGND sg13g2_fill_1
XFILLER_24_480 VPWR VGND sg13g2_decap_8
XFILLER_7_112 VPWR VGND sg13g2_decap_8
XFILLER_3_340 VPWR VGND sg13g2_decap_8
X_0460_ VPWR _0024_ state\[63\] VGND sg13g2_inv_1
XFILLER_7_189 VPWR VGND sg13g2_decap_8
XFILLER_19_252 VPWR VGND sg13g2_decap_8
X_1012_ net113 VGND VPWR _0172_ state\[44\] clknet_5_21__leaf_clk sg13g2_dfrbpq_1
XFILLER_34_222 VPWR VGND sg13g2_decap_8
XFILLER_34_299 VPWR VGND sg13g2_decap_8
Xheichips25_pudding_124 VPWR VGND uio_oe[5] sg13g2_tiehi
XFILLER_30_494 VPWR VGND sg13g2_decap_8
X_0727_ _0280_ VPWR _0135_ VGND net79 _0061_ sg13g2_o21ai_1
XFILLER_8_83 VPWR VGND sg13g2_decap_8
X_0658_ _0112_ _0403_ _0404_ net50 _0241_ VPWR VGND sg13g2_a22oi_1
X_0589_ VGND VPWR net25 daisychain\[30\] _0353_ net42 sg13g2_a21oi_1
XFILLER_13_406 VPWR VGND sg13g2_decap_8
XFILLER_25_211 VPWR VGND sg13g2_decap_8
XFILLER_43_14 VPWR VGND sg13g2_decap_8
XFILLER_25_288 VPWR VGND sg13g2_decap_8
XFILLER_40_203 VPWR VGND sg13g2_decap_8
XFILLER_41_737 VPWR VGND sg13g2_decap_8
XFILLER_4_137 VPWR VGND sg13g2_decap_8
XFILLER_0_343 VPWR VGND sg13g2_decap_8
XFILLER_48_336 VPWR VGND sg13g2_decap_8
XFILLER_16_211 VPWR VGND sg13g2_decap_8
XFILLER_16_288 VPWR VGND sg13g2_decap_8
XFILLER_17_70 VPWR VGND sg13g2_decap_8
XFILLER_29_594 VPWR VGND sg13g2_decap_8
XFILLER_31_214 VPWR VGND sg13g2_decap_8
XFILLER_32_737 VPWR VGND sg13g2_fill_1
XFILLER_44_553 VPWR VGND sg13g2_decap_8
XFILLER_12_494 VPWR VGND sg13g2_decap_8
XFILLER_8_454 VPWR VGND sg13g2_decap_8
X_0512_ _0205_ net61 _0294_ _0295_ VPWR VGND sg13g2_a21o_1
XFILLER_35_564 VPWR VGND sg13g2_decap_8
XFILLER_39_336 VPWR VGND sg13g2_decap_8
XFILLER_13_17 VPWR VGND sg13g2_decap_8
XFILLER_22_258 VPWR VGND sg13g2_decap_8
XFILLER_23_737 VPWR VGND sg13g2_decap_8
XFILLER_30_291 VPWR VGND sg13g2_decap_8
Xclkbuf_5_1__f_clk clknet_5_1__leaf_clk clknet_4_0_0_clk VPWR VGND sg13g2_buf_16
Xfanout29 net30 net29 VPWR VGND sg13g2_buf_1
XFILLER_38_14 VPWR VGND sg13g2_decap_8
XFILLER_38_69 VPWR VGND sg13g2_decap_8
XFILLER_26_575 VPWR VGND sg13g2_decap_8
XFILLER_38_391 VPWR VGND sg13g2_decap_8
XFILLER_41_567 VPWR VGND sg13g2_decap_8
XFILLER_9_207 VPWR VGND sg13g2_decap_8
XFILLER_13_269 VPWR VGND sg13g2_decap_8
XFILLER_5_424 VPWR VGND sg13g2_decap_8
XFILLER_0_140 VPWR VGND sg13g2_decap_8
XFILLER_49_634 VPWR VGND sg13g2_decap_8
XFILLER_17_553 VPWR VGND sg13g2_decap_8
XFILLER_29_391 VPWR VGND sg13g2_decap_8
XFILLER_36_328 VPWR VGND sg13g2_decap_8
XFILLER_44_350 VPWR VGND sg13g2_decap_8
XFILLER_48_133 VPWR VGND sg13g2_decap_8
XFILLER_13_781 VPWR VGND sg13g2_fill_1
XFILLER_32_512 VPWR VGND sg13g2_decap_8
XFILLER_32_589 VPWR VGND sg13g2_decap_8
X_0992_ net105 VGND VPWR _0152_ state\[24\] clknet_5_6__leaf_clk sg13g2_dfrbpq_1
XFILLER_8_251 VPWR VGND sg13g2_decap_8
XFILLER_28_818 VPWR VGND sg13g2_decap_4
XFILLER_39_133 VPWR VGND sg13g2_decap_8
Xclkbuf_4_7_0_clk clknet_0_clk clknet_4_7_0_clk VPWR VGND sg13g2_buf_8
XFILLER_5_95 VPWR VGND sg13g2_decap_8
XFILLER_23_556 VPWR VGND sg13g2_decap_8
XFILLER_35_361 VPWR VGND sg13g2_decap_8
XFILLER_2_438 VPWR VGND sg13g2_decap_8
XFILLER_49_46 VPWR VGND sg13g2_decap_8
XFILLER_45_147 VPWR VGND sg13g2_decap_8
XFILLER_46_637 VPWR VGND sg13g2_decap_8
XFILLER_14_545 VPWR VGND sg13g2_decap_8
XFILLER_26_372 VPWR VGND sg13g2_decap_8
XFILLER_41_364 VPWR VGND sg13g2_decap_8
XFILLER_30_81 VPWR VGND sg13g2_decap_8
XFILLER_5_298 VPWR VGND sg13g2_decap_8
XFILLER_5_221 VPWR VGND sg13g2_decap_8
XFILLER_39_7 VPWR VGND sg13g2_decap_8
XFILLER_49_431 VPWR VGND sg13g2_decap_8
XFILLER_17_350 VPWR VGND sg13g2_decap_8
XFILLER_24_309 VPWR VGND sg13g2_decap_8
XFILLER_36_125 VPWR VGND sg13g2_decap_8
XFILLER_20_526 VPWR VGND sg13g2_decap_8
XFILLER_32_386 VPWR VGND sg13g2_decap_8
X_0975_ net101 VGND VPWR _0135_ state\[7\] clknet_5_13__leaf_clk sg13g2_dfrbpq_1
XFILLER_19_49 VPWR VGND sg13g2_decap_8
XFILLER_27_147 VPWR VGND sg13g2_decap_8
XFILLER_28_648 VPWR VGND sg13g2_decap_8
XFILLER_28_659 VPWR VGND sg13g2_fill_1
XFILLER_23_353 VPWR VGND sg13g2_decap_8
XFILLER_24_810 VPWR VGND sg13g2_decap_8
XFILLER_24_821 VPWR VGND sg13g2_fill_2
XFILLER_2_235 VPWR VGND sg13g2_decap_8
XFILLER_4_4 VPWR VGND sg13g2_decap_8
XFILLER_15_810 VPWR VGND sg13g2_decap_8
XFILLER_15_821 VPWR VGND sg13g2_fill_2
XFILLER_18_169 VPWR VGND sg13g2_decap_8
XFILLER_19_637 VPWR VGND sg13g2_decap_8
XFILLER_33_139 VPWR VGND sg13g2_decap_8
XFILLER_34_607 VPWR VGND sg13g2_decap_8
XFILLER_46_434 VPWR VGND sg13g2_decap_8
XFILLER_10_570 VPWR VGND sg13g2_fill_2
XFILLER_10_581 VPWR VGND sg13g2_decap_8
XFILLER_14_342 VPWR VGND sg13g2_decap_8
XFILLER_25_92 VPWR VGND sg13g2_decap_8
XFILLER_41_161 VPWR VGND sg13g2_decap_8
X_0760_ _0379_ VPWR _0168_ VGND net89 _0030_ sg13g2_o21ai_1
XFILLER_37_4 VPWR VGND sg13g2_fill_1
XFILLER_41_91 VPWR VGND sg13g2_decap_8
X_0691_ net76 VPWR _0429_ VGND net55 state\[57\] sg13g2_o21ai_1
XFILLER_6_530 VPWR VGND sg13g2_decap_8
XFILLER_2_74 VPWR VGND sg13g2_decap_8
XFILLER_37_412 VPWR VGND sg13g2_decap_8
XFILLER_20_323 VPWR VGND sg13g2_decap_8
XFILLER_24_106 VPWR VGND sg13g2_decap_8
XFILLER_32_183 VPWR VGND sg13g2_decap_8
X_0889_ VPWR _0244_ daisychain\[51\] VGND sg13g2_inv_1
X_0958_ net111 VGND VPWR _0118_ daisychain\[54\] clknet_5_30__leaf_clk sg13g2_dfrbpq_1
XFILLER_0_706 VPWR VGND sg13g2_fill_2
XFILLER_0_728 VPWR VGND sg13g2_decap_8
XFILLER_15_139 VPWR VGND sg13g2_decap_8
XFILLER_28_445 VPWR VGND sg13g2_decap_8
XFILLER_43_448 VPWR VGND sg13g2_decap_8
XFILLER_46_14 VPWR VGND sg13g2_decap_8
XFILLER_11_312 VPWR VGND sg13g2_decap_8
XFILLER_11_389 VPWR VGND sg13g2_decap_8
XFILLER_23_150 VPWR VGND sg13g2_decap_8
XFILLER_24_662 VPWR VGND sg13g2_decap_8
XFILLER_30_109 VPWR VGND sg13g2_decap_8
XFILLER_3_522 VPWR VGND sg13g2_decap_8
XFILLER_19_434 VPWR VGND sg13g2_decap_8
XFILLER_38_209 VPWR VGND sg13g2_decap_8
XFILLER_46_231 VPWR VGND sg13g2_decap_8
XFILLER_47_721 VPWR VGND sg13g2_decap_8
XFILLER_34_404 VPWR VGND sg13g2_decap_8
XFILLER_30_687 VPWR VGND sg13g2_decap_8
X_0812_ VPWR _0036_ state\[13\] VGND sg13g2_inv_1
X_0743_ _0328_ VPWR _0151_ VGND net84 _0047_ sg13g2_o21ai_1
XFILLER_29_209 VPWR VGND sg13g2_decap_8
X_0674_ _0116_ _0415_ _0416_ net50 _0245_ VPWR VGND sg13g2_a22oi_1
XFILLER_37_286 VPWR VGND sg13g2_decap_8
XFILLER_20_120 VPWR VGND sg13g2_decap_8
XFILLER_21_610 VPWR VGND sg13g2_decap_8
XFILLER_21_687 VPWR VGND sg13g2_decap_8
XFILLER_20_197 VPWR VGND sg13g2_decap_8
XFILLER_4_319 VPWR VGND sg13g2_decap_8
XFILLER_0_525 VPWR VGND sg13g2_decap_8
XFILLER_48_518 VPWR VGND sg13g2_decap_8
XFILLER_28_242 VPWR VGND sg13g2_decap_8
XFILLER_29_787 VPWR VGND sg13g2_fill_1
XFILLER_43_245 VPWR VGND sg13g2_decap_8
XFILLER_44_724 VPWR VGND sg13g2_fill_1
XFILLER_11_186 VPWR VGND sg13g2_decap_8
XFILLER_7_168 VPWR VGND sg13g2_decap_8
XFILLER_3_396 VPWR VGND sg13g2_decap_8
XFILLER_14_6 VPWR VGND sg13g2_fill_1
XFILLER_19_231 VPWR VGND sg13g2_decap_8
XFILLER_34_201 VPWR VGND sg13g2_decap_8
XFILLER_47_595 VPWR VGND sg13g2_decap_8
X_1011_ net113 VGND VPWR _0171_ state\[43\] clknet_5_16__leaf_clk sg13g2_dfrbpq_1
XFILLER_30_473 VPWR VGND sg13g2_decap_8
XFILLER_34_278 VPWR VGND sg13g2_decap_8
Xheichips25_pudding_125 VPWR VGND uio_oe[6] sg13g2_tiehi
X_0726_ _0277_ VPWR _0134_ VGND net79 _0060_ sg13g2_o21ai_1
XFILLER_8_62 VPWR VGND sg13g2_decap_8
XFILLER_38_540 VPWR VGND sg13g2_fill_2
X_0657_ VGND VPWR net28 daisychain\[47\] _0404_ net50 sg13g2_a21oi_1
X_0588_ _0224_ net64 _0351_ _0352_ VPWR VGND sg13g2_a21o_1
XFILLER_25_267 VPWR VGND sg13g2_decap_8
XFILLER_26_702 VPWR VGND sg13g2_fill_2
XFILLER_27_49 VPWR VGND sg13g2_decap_8
XFILLER_38_595 VPWR VGND sg13g2_decap_4
XFILLER_21_484 VPWR VGND sg13g2_decap_8
XFILLER_40_259 VPWR VGND sg13g2_decap_8
XFILLER_5_617 VPWR VGND sg13g2_decap_8
XFILLER_0_322 VPWR VGND sg13g2_decap_8
XFILLER_4_116 VPWR VGND sg13g2_decap_8
XFILLER_49_816 VPWR VGND sg13g2_decap_8
XFILLER_0_399 VPWR VGND sg13g2_decap_8
XFILLER_29_573 VPWR VGND sg13g2_decap_8
XFILLER_44_532 VPWR VGND sg13g2_decap_8
XFILLER_48_315 VPWR VGND sg13g2_decap_8
XFILLER_12_473 VPWR VGND sg13g2_decap_8
XFILLER_16_267 VPWR VGND sg13g2_decap_8
X_0511_ net83 VPWR _0294_ VGND net61 state\[12\] sg13g2_o21ai_1
XFILLER_8_433 VPWR VGND sg13g2_decap_8
XFILLER_39_315 VPWR VGND sg13g2_decap_8
XFILLER_3_193 VPWR VGND sg13g2_decap_8
XFILLER_35_543 VPWR VGND sg13g2_decap_8
XFILLER_47_392 VPWR VGND sg13g2_decap_8
XFILLER_22_237 VPWR VGND sg13g2_decap_8
XFILLER_30_270 VPWR VGND sg13g2_decap_8
XFILLER_1_119 VPWR VGND sg13g2_decap_8
X_0709_ VGND VPWR net32 daisychain\[60\] _0443_ net33 sg13g2_a21oi_1
XFILLER_38_370 VPWR VGND sg13g2_decap_8
XFILLER_45_329 VPWR VGND sg13g2_decap_8
XFILLER_13_248 VPWR VGND sg13g2_decap_8
XFILLER_26_554 VPWR VGND sg13g2_decap_8
XFILLER_41_546 VPWR VGND sg13g2_decap_8
XFILLER_21_281 VPWR VGND sg13g2_decap_8
XFILLER_5_403 VPWR VGND sg13g2_decap_8
XFILLER_0_196 VPWR VGND sg13g2_decap_8
XFILLER_1_664 VPWR VGND sg13g2_fill_2
XFILLER_48_112 VPWR VGND sg13g2_decap_8
XFILLER_49_613 VPWR VGND sg13g2_decap_8
XFILLER_17_532 VPWR VGND sg13g2_decap_8
XFILLER_28_81 VPWR VGND sg13g2_decap_8
XFILLER_29_370 VPWR VGND sg13g2_decap_8
XFILLER_36_307 VPWR VGND sg13g2_decap_8
XFILLER_48_189 VPWR VGND sg13g2_decap_8
XFILLER_20_708 VPWR VGND sg13g2_fill_2
XFILLER_32_568 VPWR VGND sg13g2_decap_8
XFILLER_44_91 VPWR VGND sg13g2_decap_8
X_0991_ net105 VGND VPWR _0151_ state\[23\] clknet_5_0__leaf_clk sg13g2_dfrbpq_1
XFILLER_8_230 VPWR VGND sg13g2_decap_8
XFILLER_5_74 VPWR VGND sg13g2_decap_8
XFILLER_4_480 VPWR VGND sg13g2_decap_8
XFILLER_27_329 VPWR VGND sg13g2_decap_8
XFILLER_39_112 VPWR VGND sg13g2_decap_8
XFILLER_39_189 VPWR VGND sg13g2_decap_8
XFILLER_23_535 VPWR VGND sg13g2_decap_8
XFILLER_35_340 VPWR VGND sg13g2_decap_8
XFILLER_40_49 VPWR VGND sg13g2_decap_8
XFILLER_2_417 VPWR VGND sg13g2_decap_8
XFILLER_49_25 VPWR VGND sg13g2_decap_8
XFILLER_26_351 VPWR VGND sg13g2_decap_8
XFILLER_39_690 VPWR VGND sg13g2_decap_8
XFILLER_42_811 VPWR VGND sg13g2_decap_8
XFILLER_42_822 VPWR VGND sg13g2_fill_1
XFILLER_45_126 VPWR VGND sg13g2_decap_8
XFILLER_46_616 VPWR VGND sg13g2_decap_8
XFILLER_14_524 VPWR VGND sg13g2_decap_8
XFILLER_14_83 VPWR VGND sg13g2_decap_8
XFILLER_41_343 VPWR VGND sg13g2_decap_8
XFILLER_30_60 VPWR VGND sg13g2_decap_8
XFILLER_5_277 VPWR VGND sg13g2_decap_8
XFILLER_5_200 VPWR VGND sg13g2_decap_8
XFILLER_1_483 VPWR VGND sg13g2_decap_8
XFILLER_36_104 VPWR VGND sg13g2_decap_8
XFILLER_37_638 VPWR VGND sg13g2_fill_1
XFILLER_39_91 VPWR VGND sg13g2_decap_8
XFILLER_49_487 VPWR VGND sg13g2_decap_8
XFILLER_49_410 VPWR VGND sg13g2_decap_8
XFILLER_20_505 VPWR VGND sg13g2_decap_8
XFILLER_32_365 VPWR VGND sg13g2_decap_8
X_0974_ net102 VGND VPWR _0134_ state\[6\] clknet_5_2__leaf_clk sg13g2_dfrbpq_1
XFILLER_19_28 VPWR VGND sg13g2_decap_8
XFILLER_27_126 VPWR VGND sg13g2_decap_8
XFILLER_28_627 VPWR VGND sg13g2_decap_8
XFILLER_36_671 VPWR VGND sg13g2_decap_4
XFILLER_11_549 VPWR VGND sg13g2_decap_8
XFILLER_23_332 VPWR VGND sg13g2_decap_8
XFILLER_2_214 VPWR VGND sg13g2_decap_8
XFILLER_19_616 VPWR VGND sg13g2_decap_8
XFILLER_46_413 VPWR VGND sg13g2_decap_8
XFILLER_14_321 VPWR VGND sg13g2_decap_8
XFILLER_18_148 VPWR VGND sg13g2_decap_8
XFILLER_25_71 VPWR VGND sg13g2_decap_8
XFILLER_33_118 VPWR VGND sg13g2_decap_8
XFILLER_41_140 VPWR VGND sg13g2_decap_8
XFILLER_42_630 VPWR VGND sg13g2_decap_8
XFILLER_14_398 VPWR VGND sg13g2_decap_8
XFILLER_41_70 VPWR VGND sg13g2_decap_8
Xclkbuf_4_6_0_clk clknet_0_clk clknet_4_6_0_clk VPWR VGND sg13g2_buf_8
X_0690_ _0120_ _0427_ _0428_ net45 _0249_ VPWR VGND sg13g2_a22oi_1
XFILLER_2_770 VPWR VGND sg13g2_decap_8
XFILLER_1_280 VPWR VGND sg13g2_decap_8
XFILLER_2_53 VPWR VGND sg13g2_decap_8
XFILLER_49_284 VPWR VGND sg13g2_decap_8
XFILLER_20_302 VPWR VGND sg13g2_decap_8
XFILLER_21_814 VPWR VGND sg13g2_decap_8
XFILLER_32_162 VPWR VGND sg13g2_decap_8
XFILLER_33_685 VPWR VGND sg13g2_fill_2
XFILLER_45_490 VPWR VGND sg13g2_decap_8
XFILLER_20_379 VPWR VGND sg13g2_decap_8
XFILLER_21_29 VPWR VGND sg13g2_decap_8
X_0888_ VPWR _0010_ state\[51\] VGND sg13g2_inv_1
X_0957_ net111 VGND VPWR _0117_ daisychain\[53\] clknet_5_30__leaf_clk sg13g2_dfrbpq_1
XFILLER_28_424 VPWR VGND sg13g2_decap_8
XFILLER_15_118 VPWR VGND sg13g2_decap_8
XFILLER_24_641 VPWR VGND sg13g2_decap_8
XFILLER_43_427 VPWR VGND sg13g2_decap_8
XFILLER_11_368 VPWR VGND sg13g2_decap_8
XFILLER_11_95 VPWR VGND sg13g2_decap_8
XFILLER_3_501 VPWR VGND sg13g2_decap_8
XFILLER_19_413 VPWR VGND sg13g2_decap_8
XFILLER_46_210 VPWR VGND sg13g2_decap_8
XFILLER_47_700 VPWR VGND sg13g2_decap_8
XFILLER_47_744 VPWR VGND sg13g2_decap_8
XFILLER_14_195 VPWR VGND sg13g2_decap_8
XFILLER_15_663 VPWR VGND sg13g2_decap_8
XFILLER_27_490 VPWR VGND sg13g2_decap_8
XFILLER_46_287 VPWR VGND sg13g2_decap_8
X_0811_ VPWR _0205_ daisychain\[12\] VGND sg13g2_inv_1
X_0742_ _0325_ VPWR _0150_ VGND net86 _0046_ sg13g2_o21ai_1
X_0673_ VGND VPWR net30 daisychain\[51\] _0416_ net50 sg13g2_a21oi_1
XFILLER_6_383 VPWR VGND sg13g2_decap_8
XFILLER_38_711 VPWR VGND sg13g2_decap_4
XFILLER_16_29 VPWR VGND sg13g2_decap_8
XFILLER_25_449 VPWR VGND sg13g2_decap_8
XFILLER_37_265 VPWR VGND sg13g2_decap_8
XFILLER_20_176 VPWR VGND sg13g2_decap_8
XFILLER_21_666 VPWR VGND sg13g2_decap_8
XFILLER_33_482 VPWR VGND sg13g2_decap_8
XFILLER_0_504 VPWR VGND sg13g2_decap_8
XFILLER_28_221 VPWR VGND sg13g2_decap_8
XFILLER_16_449 VPWR VGND sg13g2_decap_8
XFILLER_28_298 VPWR VGND sg13g2_decap_8
XFILLER_43_224 VPWR VGND sg13g2_decap_8
XFILLER_11_165 VPWR VGND sg13g2_decap_8
XFILLER_22_83 VPWR VGND sg13g2_decap_8
XFILLER_7_147 VPWR VGND sg13g2_decap_8
XFILLER_3_375 VPWR VGND sg13g2_decap_8
XFILLER_19_210 VPWR VGND sg13g2_decap_8
XFILLER_19_287 VPWR VGND sg13g2_decap_8
XFILLER_34_257 VPWR VGND sg13g2_decap_8
XFILLER_47_574 VPWR VGND sg13g2_decap_8
XFILLER_47_91 VPWR VGND sg13g2_decap_8
X_1010_ net114 VGND VPWR _0170_ state\[42\] clknet_5_17__leaf_clk sg13g2_dfrbpq_1
Xheichips25_pudding_126 VPWR VGND uio_oe[7] sg13g2_tiehi
XFILLER_15_482 VPWR VGND sg13g2_decap_8
XFILLER_22_419 VPWR VGND sg13g2_decap_8
XFILLER_30_452 VPWR VGND sg13g2_decap_8
XFILLER_8_41 VPWR VGND sg13g2_decap_8
XFILLER_40_0 VPWR VGND sg13g2_decap_8
X_0725_ _0274_ VPWR _0133_ VGND net79 _0059_ sg13g2_o21ai_1
X_0656_ _0241_ net72 _0402_ _0403_ VPWR VGND sg13g2_a21o_1
XFILLER_6_180 VPWR VGND sg13g2_decap_8
XFILLER_27_28 VPWR VGND sg13g2_decap_8
XFILLER_38_574 VPWR VGND sg13g2_decap_8
X_0587_ net86 VPWR _0351_ VGND net64 state\[31\] sg13g2_o21ai_1
XFILLER_25_246 VPWR VGND sg13g2_decap_8
XFILLER_40_238 VPWR VGND sg13g2_decap_8
XFILLER_43_49 VPWR VGND sg13g2_decap_8
XFILLER_21_463 VPWR VGND sg13g2_decap_8
XFILLER_0_301 VPWR VGND sg13g2_decap_8
XFILLER_0_378 VPWR VGND sg13g2_decap_8
XFILLER_16_246 VPWR VGND sg13g2_decap_8
XFILLER_29_552 VPWR VGND sg13g2_decap_8
XFILLER_44_511 VPWR VGND sg13g2_decap_8
Xclkbuf_5_26__f_clk clknet_5_26__leaf_clk clknet_4_13_0_clk VPWR VGND sg13g2_buf_16
XFILLER_12_452 VPWR VGND sg13g2_decap_8
XFILLER_31_249 VPWR VGND sg13g2_decap_8
XFILLER_44_588 VPWR VGND sg13g2_decap_8
XFILLER_8_412 VPWR VGND sg13g2_decap_8
XFILLER_3_172 VPWR VGND sg13g2_decap_8
X_0510_ _0075_ _0292_ _0293_ net36 _0204_ VPWR VGND sg13g2_a22oi_1
XFILLER_8_489 VPWR VGND sg13g2_decap_8
XFILLER_22_216 VPWR VGND sg13g2_decap_8
XFILLER_35_522 VPWR VGND sg13g2_decap_8
XFILLER_35_599 VPWR VGND sg13g2_decap_8
XFILLER_47_371 VPWR VGND sg13g2_decap_8
X_0708_ _0254_ net55 _0441_ _0442_ VPWR VGND sg13g2_a21o_1
X_0639_ net92 VPWR _0390_ VGND net70 state\[44\] sg13g2_o21ai_1
XFILLER_26_533 VPWR VGND sg13g2_decap_8
XFILLER_45_308 VPWR VGND sg13g2_decap_8
XFILLER_13_227 VPWR VGND sg13g2_decap_8
XFILLER_21_260 VPWR VGND sg13g2_decap_8
XFILLER_41_525 VPWR VGND sg13g2_decap_8
XFILLER_5_459 VPWR VGND sg13g2_decap_8
XFILLER_0_175 VPWR VGND sg13g2_decap_8
XFILLER_48_168 VPWR VGND sg13g2_decap_8
XFILLER_49_669 VPWR VGND sg13g2_decap_8
XFILLER_17_511 VPWR VGND sg13g2_decap_8
XFILLER_17_588 VPWR VGND sg13g2_decap_8
XFILLER_28_60 VPWR VGND sg13g2_decap_8
XFILLER_32_547 VPWR VGND sg13g2_decap_8
XFILLER_44_385 VPWR VGND sg13g2_decap_8
XFILLER_44_70 VPWR VGND sg13g2_decap_8
XFILLER_12_293 VPWR VGND sg13g2_decap_8
X_0990_ net106 VGND VPWR _0150_ state\[22\] clknet_5_5__leaf_clk sg13g2_dfrbpq_1
XFILLER_9_743 VPWR VGND sg13g2_fill_1
XFILLER_9_732 VPWR VGND sg13g2_decap_8
XFILLER_8_286 VPWR VGND sg13g2_decap_8
XFILLER_5_53 VPWR VGND sg13g2_decap_8
XFILLER_27_308 VPWR VGND sg13g2_decap_8
XFILLER_39_168 VPWR VGND sg13g2_decap_8
XFILLER_23_514 VPWR VGND sg13g2_decap_8
XFILLER_35_396 VPWR VGND sg13g2_decap_8
XFILLER_40_28 VPWR VGND sg13g2_decap_8
XFILLER_14_503 VPWR VGND sg13g2_decap_8
XFILLER_26_330 VPWR VGND sg13g2_decap_8
XFILLER_41_322 VPWR VGND sg13g2_decap_8
XFILLER_45_105 VPWR VGND sg13g2_decap_8
XFILLER_14_62 VPWR VGND sg13g2_decap_8
XFILLER_22_580 VPWR VGND sg13g2_decap_8
XFILLER_41_399 VPWR VGND sg13g2_decap_8
XFILLER_6_713 VPWR VGND sg13g2_fill_2
XFILLER_1_462 VPWR VGND sg13g2_decap_8
XFILLER_5_256 VPWR VGND sg13g2_decap_8
XFILLER_39_70 VPWR VGND sg13g2_decap_8
XFILLER_49_466 VPWR VGND sg13g2_decap_8
XFILLER_17_385 VPWR VGND sg13g2_decap_8
XFILLER_32_344 VPWR VGND sg13g2_decap_8
XFILLER_44_182 VPWR VGND sg13g2_decap_8
XFILLER_45_672 VPWR VGND sg13g2_decap_4
X_0973_ net101 VGND VPWR _0133_ state\[5\] clknet_5_13__leaf_clk sg13g2_dfrbpq_1
XFILLER_9_551 VPWR VGND sg13g2_decap_8
XFILLER_28_606 VPWR VGND sg13g2_decap_8
XFILLER_23_311 VPWR VGND sg13g2_decap_8
XFILLER_27_105 VPWR VGND sg13g2_decap_8
XFILLER_35_39 VPWR VGND sg13g2_decap_8
XFILLER_42_119 VPWR VGND sg13g2_decap_8
XFILLER_43_609 VPWR VGND sg13g2_decap_8
XFILLER_11_528 VPWR VGND sg13g2_decap_8
XFILLER_23_388 VPWR VGND sg13g2_decap_8
XFILLER_35_193 VPWR VGND sg13g2_decap_8
XFILLER_18_127 VPWR VGND sg13g2_decap_8
XFILLER_14_300 VPWR VGND sg13g2_decap_8
XFILLER_14_377 VPWR VGND sg13g2_decap_8
XFILLER_25_50 VPWR VGND sg13g2_decap_8
XFILLER_27_672 VPWR VGND sg13g2_fill_1
XFILLER_30_804 VPWR VGND sg13g2_fill_2
XFILLER_42_686 VPWR VGND sg13g2_fill_2
XFILLER_46_469 VPWR VGND sg13g2_decap_8
XFILLER_41_196 VPWR VGND sg13g2_decap_8
XFILLER_6_587 VPWR VGND sg13g2_fill_1
XFILLER_2_32 VPWR VGND sg13g2_decap_8
XFILLER_44_7 VPWR VGND sg13g2_decap_8
Xheichips25_pudding VPWR VGND uio_oe[0] sg13g2_tiehi
XFILLER_17_182 VPWR VGND sg13g2_decap_8
XFILLER_37_447 VPWR VGND sg13g2_decap_8
XFILLER_49_263 VPWR VGND sg13g2_decap_8
XFILLER_20_358 VPWR VGND sg13g2_decap_8
XFILLER_32_141 VPWR VGND sg13g2_decap_8
X_0956_ net110 VGND VPWR _0116_ daisychain\[52\] clknet_5_30__leaf_clk sg13g2_dfrbpq_1
XFILLER_0_708 VPWR VGND sg13g2_fill_1
X_0887_ VPWR _0243_ daisychain\[50\] VGND sg13g2_inv_1
XFILLER_28_403 VPWR VGND sg13g2_decap_8
XFILLER_46_49 VPWR VGND sg13g2_decap_8
Xclkbuf_5_7__f_clk clknet_5_7__leaf_clk clknet_4_3_0_clk VPWR VGND sg13g2_buf_16
XFILLER_24_620 VPWR VGND sg13g2_decap_8
XFILLER_43_406 VPWR VGND sg13g2_decap_8
XFILLER_11_347 VPWR VGND sg13g2_decap_8
XFILLER_23_185 VPWR VGND sg13g2_decap_8
XFILLER_7_329 VPWR VGND sg13g2_decap_8
XFILLER_11_74 VPWR VGND sg13g2_decap_8
XFILLER_3_568 VPWR VGND sg13g2_decap_4
XFILLER_19_469 VPWR VGND sg13g2_decap_8
XFILLER_34_439 VPWR VGND sg13g2_decap_8
XFILLER_46_266 VPWR VGND sg13g2_decap_8
XFILLER_47_756 VPWR VGND sg13g2_fill_1
XFILLER_14_174 VPWR VGND sg13g2_decap_8
XFILLER_30_634 VPWR VGND sg13g2_fill_2
XFILLER_42_483 VPWR VGND sg13g2_decap_8
X_0810_ VPWR _0035_ state\[12\] VGND sg13g2_inv_1
XFILLER_10_391 VPWR VGND sg13g2_decap_8
X_0741_ _0322_ VPWR _0149_ VGND net86 _0045_ sg13g2_o21ai_1
X_0672_ _0245_ net71 _0414_ _0415_ VPWR VGND sg13g2_a21o_1
XFILLER_6_362 VPWR VGND sg13g2_decap_8
XFILLER_18_491 VPWR VGND sg13g2_decap_8
XFILLER_25_428 VPWR VGND sg13g2_decap_8
XFILLER_33_461 VPWR VGND sg13g2_decap_8
XFILLER_37_244 VPWR VGND sg13g2_decap_8
XFILLER_20_155 VPWR VGND sg13g2_decap_8
XFILLER_21_645 VPWR VGND sg13g2_decap_8
XFILLER_32_18 VPWR VGND sg13g2_fill_1
XFILLER_32_29 VPWR VGND sg13g2_decap_8
X_0939_ net109 VGND VPWR _0099_ daisychain\[35\] clknet_5_27__leaf_clk sg13g2_dfrbpq_1
XFILLER_16_428 VPWR VGND sg13g2_decap_8
XFILLER_28_200 VPWR VGND sg13g2_decap_8
XFILLER_28_277 VPWR VGND sg13g2_decap_8
XFILLER_43_203 VPWR VGND sg13g2_decap_8
Xclkbuf_4_5_0_clk clknet_0_clk clknet_4_5_0_clk VPWR VGND sg13g2_buf_8
XFILLER_11_144 VPWR VGND sg13g2_decap_8
XFILLER_12_689 VPWR VGND sg13g2_decap_8
XFILLER_24_494 VPWR VGND sg13g2_decap_8
XFILLER_22_62 VPWR VGND sg13g2_decap_8
XFILLER_3_354 VPWR VGND sg13g2_decap_8
XFILLER_7_126 VPWR VGND sg13g2_decap_8
XFILLER_0_0 VPWR VGND sg13g2_decap_8
XFILLER_15_461 VPWR VGND sg13g2_decap_8
XFILLER_19_266 VPWR VGND sg13g2_decap_8
XFILLER_34_236 VPWR VGND sg13g2_decap_8
XFILLER_47_553 VPWR VGND sg13g2_decap_8
XFILLER_47_70 VPWR VGND sg13g2_decap_8
XFILLER_30_431 VPWR VGND sg13g2_decap_8
XFILLER_42_280 VPWR VGND sg13g2_decap_8
XFILLER_8_97 VPWR VGND sg13g2_decap_8
XFILLER_8_20 VPWR VGND sg13g2_decap_8
XFILLER_33_0 VPWR VGND sg13g2_fill_2
X_0724_ _0271_ VPWR _0132_ VGND net78 _0058_ sg13g2_o21ai_1
X_0655_ net94 VPWR _0402_ VGND net72 state\[48\] sg13g2_o21ai_1
X_0586_ _0094_ _0349_ _0350_ net42 _0223_ VPWR VGND sg13g2_a22oi_1
XFILLER_7_693 VPWR VGND sg13g2_fill_1
XFILLER_21_442 VPWR VGND sg13g2_decap_8
XFILLER_25_225 VPWR VGND sg13g2_decap_8
XFILLER_40_217 VPWR VGND sg13g2_decap_8
XFILLER_43_28 VPWR VGND sg13g2_decap_8
XFILLER_0_357 VPWR VGND sg13g2_decap_8
XFILLER_1_814 VPWR VGND sg13g2_decap_8
XFILLER_29_531 VPWR VGND sg13g2_decap_8
XFILLER_16_225 VPWR VGND sg13g2_decap_8
XFILLER_17_84 VPWR VGND sg13g2_decap_8
XFILLER_32_718 VPWR VGND sg13g2_fill_2
XFILLER_44_567 VPWR VGND sg13g2_decap_8
XFILLER_12_431 VPWR VGND sg13g2_decap_8
XFILLER_31_228 VPWR VGND sg13g2_decap_8
XFILLER_33_83 VPWR VGND sg13g2_decap_8
XFILLER_40_740 VPWR VGND sg13g2_fill_1
XFILLER_8_468 VPWR VGND sg13g2_decap_8
XFILLER_3_151 VPWR VGND sg13g2_decap_8
XFILLER_35_501 VPWR VGND sg13g2_decap_8
XFILLER_47_350 VPWR VGND sg13g2_decap_8
XFILLER_35_578 VPWR VGND sg13g2_decap_8
X_0707_ net76 VPWR _0441_ VGND net55 state\[61\] sg13g2_o21ai_1
XFILLER_7_490 VPWR VGND sg13g2_decap_8
XFILLER_38_28 VPWR VGND sg13g2_decap_8
X_0638_ _0107_ _0388_ _0389_ net48 _0236_ VPWR VGND sg13g2_a22oi_1
X_0569_ VGND VPWR net23 daisychain\[25\] _0338_ net37 sg13g2_a21oi_1
XFILLER_13_206 VPWR VGND sg13g2_decap_8
XFILLER_26_512 VPWR VGND sg13g2_decap_8
XFILLER_26_589 VPWR VGND sg13g2_decap_8
XFILLER_41_504 VPWR VGND sg13g2_decap_8
XFILLER_5_438 VPWR VGND sg13g2_decap_8
XFILLER_0_154 VPWR VGND sg13g2_decap_8
XFILLER_45_821 VPWR VGND sg13g2_fill_2
XFILLER_48_147 VPWR VGND sg13g2_decap_8
XFILLER_49_648 VPWR VGND sg13g2_decap_8
XFILLER_17_567 VPWR VGND sg13g2_decap_8
XFILLER_32_526 VPWR VGND sg13g2_decap_8
XFILLER_44_364 VPWR VGND sg13g2_decap_8
XFILLER_12_272 VPWR VGND sg13g2_decap_8
XFILLER_40_581 VPWR VGND sg13g2_decap_8
XFILLER_8_265 VPWR VGND sg13g2_decap_8
XFILLER_5_32 VPWR VGND sg13g2_decap_8
XFILLER_39_147 VPWR VGND sg13g2_decap_8
XFILLER_10_209 VPWR VGND sg13g2_decap_8
XFILLER_31_592 VPWR VGND sg13g2_decap_8
XFILLER_35_375 VPWR VGND sg13g2_decap_8
XFILLER_18_309 VPWR VGND sg13g2_decap_8
XFILLER_39_670 VPWR VGND sg13g2_decap_8
XFILLER_14_559 VPWR VGND sg13g2_decap_8
XFILLER_26_386 VPWR VGND sg13g2_decap_8
XFILLER_41_301 VPWR VGND sg13g2_decap_8
XFILLER_14_41 VPWR VGND sg13g2_decap_8
XFILLER_41_378 VPWR VGND sg13g2_decap_8
XFILLER_5_235 VPWR VGND sg13g2_decap_8
XFILLER_1_441 VPWR VGND sg13g2_decap_8
XFILLER_30_95 VPWR VGND sg13g2_decap_8
XFILLER_17_364 VPWR VGND sg13g2_decap_8
XFILLER_36_139 VPWR VGND sg13g2_decap_8
XFILLER_45_651 VPWR VGND sg13g2_decap_8
XFILLER_49_445 VPWR VGND sg13g2_decap_8
XFILLER_13_581 VPWR VGND sg13g2_decap_8
XFILLER_32_323 VPWR VGND sg13g2_decap_8
XFILLER_44_161 VPWR VGND sg13g2_decap_8
X_0972_ net101 VGND VPWR _0132_ state\[4\] clknet_5_12__leaf_clk sg13g2_dfrbpq_1
XFILLER_35_172 VPWR VGND sg13g2_decap_8
XFILLER_11_507 VPWR VGND sg13g2_decap_8
XFILLER_23_367 VPWR VGND sg13g2_decap_8
XFILLER_2_249 VPWR VGND sg13g2_decap_8
XFILLER_18_106 VPWR VGND sg13g2_decap_8
XFILLER_27_651 VPWR VGND sg13g2_decap_8
XFILLER_46_448 VPWR VGND sg13g2_decap_8
XFILLER_14_356 VPWR VGND sg13g2_decap_8
XFILLER_26_183 VPWR VGND sg13g2_decap_8
XFILLER_41_175 VPWR VGND sg13g2_decap_8
XFILLER_6_544 VPWR VGND sg13g2_fill_2
XFILLER_2_11 VPWR VGND sg13g2_decap_8
XFILLER_2_750 VPWR VGND sg13g2_fill_2
XFILLER_49_242 VPWR VGND sg13g2_decap_8
XFILLER_17_161 VPWR VGND sg13g2_decap_8
XFILLER_2_88 VPWR VGND sg13g2_decap_8
XFILLER_32_120 VPWR VGND sg13g2_decap_8
XFILLER_37_426 VPWR VGND sg13g2_decap_8
XFILLER_20_337 VPWR VGND sg13g2_decap_8
XFILLER_32_197 VPWR VGND sg13g2_decap_8
X_0886_ VPWR _0009_ state\[50\] VGND sg13g2_inv_1
X_0955_ net115 VGND VPWR _0115_ daisychain\[51\] clknet_5_28__leaf_clk sg13g2_dfrbpq_1
XFILLER_9_382 VPWR VGND sg13g2_decap_8
XFILLER_28_459 VPWR VGND sg13g2_decap_8
XFILLER_46_28 VPWR VGND sg13g2_decap_8
XFILLER_11_326 VPWR VGND sg13g2_decap_8
XFILLER_23_164 VPWR VGND sg13g2_decap_8
XFILLER_24_676 VPWR VGND sg13g2_decap_8
XFILLER_24_687 VPWR VGND sg13g2_fill_2
XFILLER_11_53 VPWR VGND sg13g2_decap_8
XFILLER_3_536 VPWR VGND sg13g2_decap_8
XFILLER_7_308 VPWR VGND sg13g2_decap_8
XFILLER_2_4 VPWR VGND sg13g2_decap_8
XFILLER_15_654 VPWR VGND sg13g2_fill_2
XFILLER_19_448 VPWR VGND sg13g2_decap_8
XFILLER_34_418 VPWR VGND sg13g2_decap_8
XFILLER_36_83 VPWR VGND sg13g2_decap_8
XFILLER_46_245 VPWR VGND sg13g2_decap_8
XFILLER_47_735 VPWR VGND sg13g2_fill_2
XFILLER_10_370 VPWR VGND sg13g2_decap_8
XFILLER_14_153 VPWR VGND sg13g2_decap_8
XFILLER_30_613 VPWR VGND sg13g2_decap_8
XFILLER_42_462 VPWR VGND sg13g2_decap_8
X_0740_ _0319_ VPWR _0148_ VGND net86 _0044_ sg13g2_o21ai_1
X_0671_ net93 VPWR _0414_ VGND net71 state\[52\] sg13g2_o21ai_1
XFILLER_6_341 VPWR VGND sg13g2_decap_8
XFILLER_25_407 VPWR VGND sg13g2_decap_8
XFILLER_37_223 VPWR VGND sg13g2_decap_8
XFILLER_18_470 VPWR VGND sg13g2_decap_8
XFILLER_21_624 VPWR VGND sg13g2_decap_8
XFILLER_33_440 VPWR VGND sg13g2_decap_8
XFILLER_20_134 VPWR VGND sg13g2_decap_8
X_0869_ VPWR _0234_ daisychain\[41\] VGND sg13g2_inv_1
X_0938_ net109 VGND VPWR _0098_ daisychain\[34\] clknet_5_18__leaf_clk sg13g2_dfrbpq_1
XFILLER_0_539 VPWR VGND sg13g2_decap_8
XFILLER_16_407 VPWR VGND sg13g2_decap_8
XFILLER_28_256 VPWR VGND sg13g2_decap_8
XFILLER_29_757 VPWR VGND sg13g2_decap_8
XFILLER_43_259 VPWR VGND sg13g2_decap_8
XFILLER_11_123 VPWR VGND sg13g2_decap_8
XFILLER_22_41 VPWR VGND sg13g2_decap_8
XFILLER_24_473 VPWR VGND sg13g2_decap_8
XFILLER_7_105 VPWR VGND sg13g2_decap_8
XFILLER_3_333 VPWR VGND sg13g2_decap_8
XFILLER_19_245 VPWR VGND sg13g2_decap_8
XFILLER_47_532 VPWR VGND sg13g2_decap_8
XFILLER_15_440 VPWR VGND sg13g2_decap_8
XFILLER_30_410 VPWR VGND sg13g2_decap_8
XFILLER_34_215 VPWR VGND sg13g2_decap_8
XFILLER_30_487 VPWR VGND sg13g2_decap_8
X_0723_ _0268_ VPWR _0131_ VGND net78 _0057_ sg13g2_o21ai_1
XFILLER_8_76 VPWR VGND sg13g2_decap_8
X_0654_ _0111_ _0400_ _0401_ net52 _0240_ VPWR VGND sg13g2_a22oi_1
X_0585_ VGND VPWR net24 daisychain\[29\] _0350_ net44 sg13g2_a21oi_1
XFILLER_25_204 VPWR VGND sg13g2_decap_8
XFILLER_21_421 VPWR VGND sg13g2_decap_8
XFILLER_21_498 VPWR VGND sg13g2_decap_8
XFILLER_41_719 VPWR VGND sg13g2_decap_8
XFILLER_0_336 VPWR VGND sg13g2_decap_8
XFILLER_29_510 VPWR VGND sg13g2_decap_8
XFILLER_48_329 VPWR VGND sg13g2_decap_8
XFILLER_12_410 VPWR VGND sg13g2_decap_8
XFILLER_16_204 VPWR VGND sg13g2_decap_8
XFILLER_17_63 VPWR VGND sg13g2_decap_8
XFILLER_24_281 VPWR VGND sg13g2_decap_8
XFILLER_29_587 VPWR VGND sg13g2_decap_8
XFILLER_31_207 VPWR VGND sg13g2_decap_8
XFILLER_44_546 VPWR VGND sg13g2_decap_8
XFILLER_12_487 VPWR VGND sg13g2_decap_8
XFILLER_33_62 VPWR VGND sg13g2_decap_8
XFILLER_8_447 VPWR VGND sg13g2_decap_8
XFILLER_3_130 VPWR VGND sg13g2_decap_8
XFILLER_35_557 VPWR VGND sg13g2_decap_8
XFILLER_39_329 VPWR VGND sg13g2_decap_8
XFILLER_30_284 VPWR VGND sg13g2_decap_8
Xclkbuf_4_4_0_clk clknet_0_clk clknet_4_4_0_clk VPWR VGND sg13g2_buf_8
X_0706_ _0124_ _0439_ _0440_ net34 _0253_ VPWR VGND sg13g2_a22oi_1
X_0637_ VGND VPWR net27 daisychain\[42\] _0389_ net49 sg13g2_a21oi_1
X_0568_ _0219_ net59 _0336_ _0337_ VPWR VGND sg13g2_a21o_1
X_0499_ net83 VPWR _0285_ VGND net61 state\[9\] sg13g2_o21ai_1
XFILLER_26_568 VPWR VGND sg13g2_decap_8
XFILLER_38_384 VPWR VGND sg13g2_decap_8
XFILLER_21_295 VPWR VGND sg13g2_decap_8
XFILLER_22_730 VPWR VGND sg13g2_decap_8
XFILLER_5_417 VPWR VGND sg13g2_decap_8
XFILLER_0_133 VPWR VGND sg13g2_decap_8
XFILLER_17_546 VPWR VGND sg13g2_decap_8
XFILLER_28_95 VPWR VGND sg13g2_decap_8
XFILLER_29_384 VPWR VGND sg13g2_decap_8
XFILLER_48_126 VPWR VGND sg13g2_decap_8
XFILLER_49_627 VPWR VGND sg13g2_decap_8
XFILLER_12_251 VPWR VGND sg13g2_decap_8
XFILLER_13_774 VPWR VGND sg13g2_decap_8
XFILLER_32_505 VPWR VGND sg13g2_decap_8
XFILLER_40_560 VPWR VGND sg13g2_decap_8
XFILLER_44_343 VPWR VGND sg13g2_decap_8
XFILLER_8_244 VPWR VGND sg13g2_decap_8
XFILLER_5_11 VPWR VGND sg13g2_decap_8
XFILLER_39_126 VPWR VGND sg13g2_decap_8
XFILLER_5_88 VPWR VGND sg13g2_decap_8
XFILLER_4_494 VPWR VGND sg13g2_decap_8
XFILLER_35_354 VPWR VGND sg13g2_decap_8
XFILLER_48_693 VPWR VGND sg13g2_decap_8
XFILLER_23_549 VPWR VGND sg13g2_decap_8
XFILLER_31_571 VPWR VGND sg13g2_decap_8
XFILLER_49_39 VPWR VGND sg13g2_decap_8
XFILLER_38_181 VPWR VGND sg13g2_decap_8
XFILLER_14_538 VPWR VGND sg13g2_decap_8
XFILLER_26_365 VPWR VGND sg13g2_decap_8
XFILLER_41_357 VPWR VGND sg13g2_decap_8
XFILLER_14_97 VPWR VGND sg13g2_decap_8
XFILLER_30_74 VPWR VGND sg13g2_decap_8
XFILLER_5_214 VPWR VGND sg13g2_decap_8
XFILLER_1_420 VPWR VGND sg13g2_decap_8
XFILLER_1_497 VPWR VGND sg13g2_decap_8
XFILLER_49_424 VPWR VGND sg13g2_decap_8
XFILLER_17_343 VPWR VGND sg13g2_decap_8
XFILLER_18_822 VPWR VGND sg13g2_fill_1
XFILLER_29_181 VPWR VGND sg13g2_decap_8
XFILLER_32_302 VPWR VGND sg13g2_decap_8
XFILLER_36_118 VPWR VGND sg13g2_decap_8
XFILLER_44_140 VPWR VGND sg13g2_decap_8
XFILLER_45_630 VPWR VGND sg13g2_decap_8
XFILLER_13_560 VPWR VGND sg13g2_decap_8
XFILLER_20_519 VPWR VGND sg13g2_decap_8
XFILLER_32_379 VPWR VGND sg13g2_decap_8
X_0971_ net99 VGND VPWR _0131_ state\[3\] clknet_5_8__leaf_clk sg13g2_dfrbpq_1
XFILLER_4_291 VPWR VGND sg13g2_decap_8
XFILLER_48_490 VPWR VGND sg13g2_decap_8
XFILLER_23_346 VPWR VGND sg13g2_decap_8
XFILLER_35_151 VPWR VGND sg13g2_decap_8
XFILLER_36_663 VPWR VGND sg13g2_fill_2
XFILLER_2_228 VPWR VGND sg13g2_decap_8
XFILLER_26_162 VPWR VGND sg13g2_decap_8
XFILLER_27_630 VPWR VGND sg13g2_decap_8
XFILLER_46_427 VPWR VGND sg13g2_decap_8
XFILLER_10_552 VPWR VGND sg13g2_decap_8
XFILLER_14_335 VPWR VGND sg13g2_decap_8
XFILLER_25_85 VPWR VGND sg13g2_decap_8
XFILLER_30_806 VPWR VGND sg13g2_fill_1
XFILLER_30_817 VPWR VGND sg13g2_decap_4
XFILLER_41_154 VPWR VGND sg13g2_decap_8
XFILLER_42_644 VPWR VGND sg13g2_decap_4
XFILLER_42_677 VPWR VGND sg13g2_fill_2
XFILLER_41_84 VPWR VGND sg13g2_decap_8
XFILLER_6_578 VPWR VGND sg13g2_fill_2
XFILLER_6_523 VPWR VGND sg13g2_decap_8
XFILLER_1_294 VPWR VGND sg13g2_decap_8
XFILLER_2_67 VPWR VGND sg13g2_decap_8
XFILLER_2_784 VPWR VGND sg13g2_decap_4
XFILLER_37_405 VPWR VGND sg13g2_decap_8
XFILLER_49_298 VPWR VGND sg13g2_decap_8
XFILLER_49_221 VPWR VGND sg13g2_decap_8
XFILLER_17_140 VPWR VGND sg13g2_decap_8
XFILLER_18_652 VPWR VGND sg13g2_decap_8
XFILLER_18_696 VPWR VGND sg13g2_fill_1
XFILLER_33_622 VPWR VGND sg13g2_fill_1
XFILLER_33_644 VPWR VGND sg13g2_fill_2
XFILLER_20_316 VPWR VGND sg13g2_decap_8
XFILLER_32_176 VPWR VGND sg13g2_decap_8
X_0885_ VPWR _0242_ daisychain\[49\] VGND sg13g2_inv_1
X_0954_ net115 VGND VPWR _0114_ daisychain\[50\] clknet_5_31__leaf_clk sg13g2_dfrbpq_1
XFILLER_9_361 VPWR VGND sg13g2_decap_8
XFILLER_28_438 VPWR VGND sg13g2_decap_8
XFILLER_11_305 VPWR VGND sg13g2_decap_8
XFILLER_23_143 VPWR VGND sg13g2_decap_8
XFILLER_24_655 VPWR VGND sg13g2_decap_8
XFILLER_36_482 VPWR VGND sg13g2_decap_8
XFILLER_11_32 VPWR VGND sg13g2_decap_8
XFILLER_3_515 VPWR VGND sg13g2_decap_8
XFILLER_19_427 VPWR VGND sg13g2_decap_8
XFILLER_46_224 VPWR VGND sg13g2_decap_8
XFILLER_47_714 VPWR VGND sg13g2_decap_8
XFILLER_14_132 VPWR VGND sg13g2_decap_8
XFILLER_15_644 VPWR VGND sg13g2_decap_4
XFILLER_15_677 VPWR VGND sg13g2_fill_2
XFILLER_36_62 VPWR VGND sg13g2_decap_8
XFILLER_42_441 VPWR VGND sg13g2_decap_8
XFILLER_30_636 VPWR VGND sg13g2_fill_1
X_0670_ _0115_ _0412_ _0413_ net51 _0244_ VPWR VGND sg13g2_a22oi_1
XFILLER_6_320 VPWR VGND sg13g2_decap_8
XFILLER_2_581 VPWR VGND sg13g2_fill_2
XFILLER_6_397 VPWR VGND sg13g2_decap_8
XFILLER_28_4 VPWR VGND sg13g2_decap_8
XFILLER_37_202 VPWR VGND sg13g2_decap_8
XFILLER_37_279 VPWR VGND sg13g2_decap_8
XFILLER_20_113 VPWR VGND sg13g2_decap_8
XFILLER_21_603 VPWR VGND sg13g2_decap_8
XFILLER_33_496 VPWR VGND sg13g2_decap_8
X_0868_ VPWR _0031_ state\[41\] VGND sg13g2_inv_1
X_0937_ net109 VGND VPWR _0097_ daisychain\[33\] clknet_5_22__leaf_clk sg13g2_dfrbpq_1
Xclkbuf_5_15__f_clk clknet_5_15__leaf_clk clknet_4_7_0_clk VPWR VGND sg13g2_buf_16
X_0799_ VPWR _0199_ daisychain\[6\] VGND sg13g2_inv_1
XFILLER_0_518 VPWR VGND sg13g2_decap_8
XFILLER_24_452 VPWR VGND sg13g2_decap_8
XFILLER_28_235 VPWR VGND sg13g2_decap_8
XFILLER_43_238 VPWR VGND sg13g2_decap_8
XFILLER_44_717 VPWR VGND sg13g2_fill_1
XFILLER_11_102 VPWR VGND sg13g2_decap_8
XFILLER_11_179 VPWR VGND sg13g2_decap_8
XFILLER_20_680 VPWR VGND sg13g2_decap_8
XFILLER_22_97 VPWR VGND sg13g2_decap_8
XFILLER_3_312 VPWR VGND sg13g2_decap_8
XFILLER_3_389 VPWR VGND sg13g2_decap_8
XFILLER_19_224 VPWR VGND sg13g2_decap_8
XFILLER_47_511 VPWR VGND sg13g2_decap_8
XFILLER_47_588 VPWR VGND sg13g2_decap_8
XFILLER_15_496 VPWR VGND sg13g2_decap_8
XFILLER_30_466 VPWR VGND sg13g2_decap_8
X_0722_ _0265_ VPWR _0130_ VGND net78 _0054_ sg13g2_o21ai_1
X_0653_ VGND VPWR net28 daisychain\[46\] _0401_ net48 sg13g2_a21oi_1
XFILLER_8_55 VPWR VGND sg13g2_decap_8
XFILLER_6_194 VPWR VGND sg13g2_decap_8
XFILLER_33_2 VPWR VGND sg13g2_fill_1
XFILLER_38_500 VPWR VGND sg13g2_decap_8
XFILLER_38_522 VPWR VGND sg13g2_decap_8
X_0584_ _0223_ net66 _0348_ _0349_ VPWR VGND sg13g2_a21o_1
XFILLER_38_588 VPWR VGND sg13g2_decap_8
XFILLER_21_400 VPWR VGND sg13g2_decap_8
XFILLER_21_477 VPWR VGND sg13g2_decap_8
XFILLER_33_293 VPWR VGND sg13g2_decap_8
XFILLER_0_315 VPWR VGND sg13g2_decap_8
XFILLER_4_109 VPWR VGND sg13g2_decap_8
XFILLER_17_728 VPWR VGND sg13g2_fill_2
XFILLER_29_566 VPWR VGND sg13g2_decap_8
XFILLER_49_809 VPWR VGND sg13g2_decap_8
XFILLER_48_308 VPWR VGND sg13g2_decap_8
XFILLER_24_260 VPWR VGND sg13g2_decap_8
XFILLER_25_783 VPWR VGND sg13g2_decap_4
XFILLER_33_41 VPWR VGND sg13g2_decap_8
XFILLER_44_525 VPWR VGND sg13g2_decap_8
XFILLER_12_466 VPWR VGND sg13g2_decap_8
XFILLER_8_426 VPWR VGND sg13g2_decap_8
XFILLER_39_308 VPWR VGND sg13g2_decap_8
XFILLER_3_186 VPWR VGND sg13g2_decap_8
XFILLER_35_536 VPWR VGND sg13g2_decap_8
XFILLER_47_385 VPWR VGND sg13g2_decap_8
XFILLER_15_293 VPWR VGND sg13g2_decap_8
XFILLER_30_263 VPWR VGND sg13g2_decap_8
XFILLER_31_731 VPWR VGND sg13g2_fill_1
X_0705_ VGND VPWR net32 daisychain\[59\] _0440_ net34 sg13g2_a21oi_1
X_0636_ _0236_ net69 _0387_ _0388_ VPWR VGND sg13g2_a21o_1
XFILLER_38_363 VPWR VGND sg13g2_decap_8
X_0567_ net79 VPWR _0336_ VGND net59 state\[26\] sg13g2_o21ai_1
X_0498_ _0072_ _0283_ _0284_ net36 _0201_ VPWR VGND sg13g2_a22oi_1
XFILLER_26_547 VPWR VGND sg13g2_decap_8
XFILLER_41_539 VPWR VGND sg13g2_decap_8
XFILLER_21_274 VPWR VGND sg13g2_decap_8
XFILLER_0_112 VPWR VGND sg13g2_decap_8
XFILLER_1_657 VPWR VGND sg13g2_decap_8
XFILLER_48_105 VPWR VGND sg13g2_decap_8
XFILLER_49_606 VPWR VGND sg13g2_decap_8
XFILLER_0_189 VPWR VGND sg13g2_decap_8
XFILLER_17_525 VPWR VGND sg13g2_decap_8
XFILLER_28_74 VPWR VGND sg13g2_decap_8
XFILLER_29_363 VPWR VGND sg13g2_decap_8
XFILLER_44_322 VPWR VGND sg13g2_decap_8
XFILLER_12_230 VPWR VGND sg13g2_decap_8
XFILLER_44_399 VPWR VGND sg13g2_decap_8
XFILLER_44_84 VPWR VGND sg13g2_decap_8
XFILLER_8_223 VPWR VGND sg13g2_decap_8
XFILLER_5_67 VPWR VGND sg13g2_decap_8
XFILLER_4_473 VPWR VGND sg13g2_decap_8
XFILLER_10_4 VPWR VGND sg13g2_decap_4
XFILLER_39_105 VPWR VGND sg13g2_decap_8
XFILLER_48_672 VPWR VGND sg13g2_decap_8
XFILLER_23_528 VPWR VGND sg13g2_decap_8
XFILLER_35_333 VPWR VGND sg13g2_decap_8
XFILLER_47_182 VPWR VGND sg13g2_decap_8
XFILLER_31_550 VPWR VGND sg13g2_decap_8
X_0619_ net93 VPWR _0375_ VGND net71 state\[39\] sg13g2_o21ai_1
XFILLER_49_18 VPWR VGND sg13g2_decap_8
XFILLER_26_344 VPWR VGND sg13g2_decap_8
XFILLER_27_801 VPWR VGND sg13g2_decap_4
XFILLER_38_160 VPWR VGND sg13g2_decap_8
XFILLER_39_661 VPWR VGND sg13g2_decap_4
XFILLER_45_119 VPWR VGND sg13g2_decap_8
XFILLER_46_609 VPWR VGND sg13g2_decap_8
XFILLER_14_517 VPWR VGND sg13g2_decap_8
XFILLER_14_76 VPWR VGND sg13g2_decap_8
XFILLER_22_594 VPWR VGND sg13g2_decap_8
XFILLER_41_336 VPWR VGND sg13g2_decap_8
XFILLER_30_53 VPWR VGND sg13g2_decap_8
XFILLER_1_476 VPWR VGND sg13g2_decap_8
XFILLER_39_84 VPWR VGND sg13g2_decap_8
Xclkbuf_4_3_0_clk clknet_0_clk clknet_4_3_0_clk VPWR VGND sg13g2_buf_8
XFILLER_49_403 VPWR VGND sg13g2_decap_8
XFILLER_17_322 VPWR VGND sg13g2_decap_8
XFILLER_17_399 VPWR VGND sg13g2_decap_8
XFILLER_29_160 VPWR VGND sg13g2_decap_8
XFILLER_44_196 VPWR VGND sg13g2_decap_8
XFILLER_32_358 VPWR VGND sg13g2_decap_8
X_0970_ net99 VGND VPWR _0130_ state\[2\] clknet_5_9__leaf_clk sg13g2_dfrbpq_1
XFILLER_9_565 VPWR VGND sg13g2_decap_8
XFILLER_4_270 VPWR VGND sg13g2_decap_8
XFILLER_27_119 VPWR VGND sg13g2_decap_8
XFILLER_35_130 VPWR VGND sg13g2_decap_8
XFILLER_23_325 VPWR VGND sg13g2_decap_8
XFILLER_36_675 VPWR VGND sg13g2_fill_1
XFILLER_2_207 VPWR VGND sg13g2_decap_8
XFILLER_19_609 VPWR VGND sg13g2_decap_8
XFILLER_46_406 VPWR VGND sg13g2_decap_8
XFILLER_14_314 VPWR VGND sg13g2_decap_8
XFILLER_15_804 VPWR VGND sg13g2_fill_2
XFILLER_26_141 VPWR VGND sg13g2_decap_8
XFILLER_42_623 VPWR VGND sg13g2_decap_8
XFILLER_22_391 VPWR VGND sg13g2_decap_8
XFILLER_25_64 VPWR VGND sg13g2_decap_8
XFILLER_41_133 VPWR VGND sg13g2_decap_8
XFILLER_41_63 VPWR VGND sg13g2_decap_8
XFILLER_6_502 VPWR VGND sg13g2_decap_8
XFILLER_6_546 VPWR VGND sg13g2_fill_1
XFILLER_18_631 VPWR VGND sg13g2_decap_8
XFILLER_1_273 VPWR VGND sg13g2_decap_8
XFILLER_2_46 VPWR VGND sg13g2_decap_8
XFILLER_49_277 VPWR VGND sg13g2_decap_8
XFILLER_49_200 VPWR VGND sg13g2_decap_8
XFILLER_17_196 VPWR VGND sg13g2_decap_8
XFILLER_21_807 VPWR VGND sg13g2_decap_8
XFILLER_32_155 VPWR VGND sg13g2_decap_8
XFILLER_33_601 VPWR VGND sg13g2_decap_8
XFILLER_33_678 VPWR VGND sg13g2_decap_8
XFILLER_45_483 VPWR VGND sg13g2_decap_8
X_0884_ VPWR _0008_ state\[49\] VGND sg13g2_inv_1
X_0953_ net116 VGND VPWR _0113_ daisychain\[49\] clknet_5_31__leaf_clk sg13g2_dfrbpq_1
XFILLER_9_340 VPWR VGND sg13g2_decap_8
XFILLER_23_122 VPWR VGND sg13g2_decap_8
XFILLER_24_634 VPWR VGND sg13g2_decap_8
XFILLER_28_417 VPWR VGND sg13g2_decap_8
XFILLER_36_461 VPWR VGND sg13g2_decap_8
XFILLER_23_199 VPWR VGND sg13g2_decap_8
XFILLER_11_11 VPWR VGND sg13g2_decap_8
XFILLER_11_88 VPWR VGND sg13g2_decap_8
XFILLER_19_406 VPWR VGND sg13g2_decap_8
XFILLER_46_203 VPWR VGND sg13g2_decap_8
XFILLER_47_737 VPWR VGND sg13g2_fill_1
XFILLER_14_111 VPWR VGND sg13g2_decap_8
XFILLER_14_188 VPWR VGND sg13g2_decap_8
XFILLER_15_601 VPWR VGND sg13g2_decap_8
XFILLER_27_483 VPWR VGND sg13g2_decap_8
XFILLER_42_420 VPWR VGND sg13g2_decap_8
XFILLER_42_497 VPWR VGND sg13g2_decap_8
XFILLER_6_376 VPWR VGND sg13g2_decap_8
XFILLER_42_7 VPWR VGND sg13g2_decap_8
XFILLER_37_258 VPWR VGND sg13g2_decap_8
XFILLER_38_715 VPWR VGND sg13g2_fill_2
XFILLER_45_280 VPWR VGND sg13g2_decap_8
XFILLER_20_169 VPWR VGND sg13g2_decap_8
XFILLER_21_659 VPWR VGND sg13g2_decap_8
XFILLER_33_475 VPWR VGND sg13g2_decap_8
X_0936_ net109 VGND VPWR _0096_ daisychain\[32\] clknet_5_22__leaf_clk sg13g2_dfrbpq_1
X_0867_ VPWR _0233_ daisychain\[40\] VGND sg13g2_inv_1
X_0798_ VPWR _0060_ state\[6\] VGND sg13g2_inv_1
XFILLER_28_214 VPWR VGND sg13g2_decap_8
XFILLER_43_217 VPWR VGND sg13g2_decap_8
XFILLER_11_158 VPWR VGND sg13g2_decap_8
XFILLER_22_76 VPWR VGND sg13g2_decap_8
XFILLER_3_368 VPWR VGND sg13g2_decap_8
XFILLER_19_203 VPWR VGND sg13g2_decap_8
XFILLER_27_280 VPWR VGND sg13g2_decap_8
XFILLER_47_567 VPWR VGND sg13g2_decap_8
XFILLER_47_84 VPWR VGND sg13g2_decap_8
XFILLER_15_475 VPWR VGND sg13g2_decap_8
XFILLER_30_445 VPWR VGND sg13g2_decap_8
XFILLER_42_294 VPWR VGND sg13g2_decap_8
Xclkbuf_5_21__f_clk clknet_5_21__leaf_clk clknet_4_10_0_clk VPWR VGND sg13g2_buf_16
XFILLER_8_34 VPWR VGND sg13g2_decap_8
X_0721_ _0262_ VPWR _0129_ VGND net78 _0043_ sg13g2_o21ai_1
X_0652_ _0240_ net70 _0399_ _0400_ VPWR VGND sg13g2_a21o_1
X_0583_ net86 VPWR _0348_ VGND net64 state\[30\] sg13g2_o21ai_1
XFILLER_6_173 VPWR VGND sg13g2_decap_8
XFILLER_25_239 VPWR VGND sg13g2_decap_8
XFILLER_33_272 VPWR VGND sg13g2_decap_8
XFILLER_38_567 VPWR VGND sg13g2_decap_8
Xdigitalen.g\[0\].u.inv1 VPWR digitalen.g\[0\].u.OUTN net6 VGND sg13g2_inv_1
XFILLER_21_456 VPWR VGND sg13g2_decap_8
X_0919_ net108 VGND VPWR _0079_ daisychain\[15\] clknet_5_3__leaf_clk sg13g2_dfrbpq_1
XFILLER_16_239 VPWR VGND sg13g2_decap_8
XFILLER_29_545 VPWR VGND sg13g2_decap_8
XFILLER_44_504 VPWR VGND sg13g2_decap_8
XFILLER_12_445 VPWR VGND sg13g2_decap_8
XFILLER_17_98 VPWR VGND sg13g2_decap_8
XFILLER_8_405 VPWR VGND sg13g2_decap_8
XFILLER_33_97 VPWR VGND sg13g2_decap_8
XFILLER_12_8 VPWR VGND sg13g2_fill_1
XFILLER_3_165 VPWR VGND sg13g2_decap_8
XFILLER_22_209 VPWR VGND sg13g2_decap_8
XFILLER_35_515 VPWR VGND sg13g2_decap_8
XFILLER_47_364 VPWR VGND sg13g2_decap_8
XFILLER_15_272 VPWR VGND sg13g2_decap_8
XFILLER_30_242 VPWR VGND sg13g2_decap_8
XFILLER_43_581 VPWR VGND sg13g2_decap_8
X_0704_ _0253_ net56 _0438_ _0439_ VPWR VGND sg13g2_a21o_1
X_0635_ net91 VPWR _0387_ VGND net69 state\[43\] sg13g2_o21ai_1
X_0566_ _0089_ _0334_ _0335_ net38 _0218_ VPWR VGND sg13g2_a22oi_1
XFILLER_26_526 VPWR VGND sg13g2_decap_8
XFILLER_38_342 VPWR VGND sg13g2_decap_8
X_0497_ VGND VPWR net23 daisychain\[7\] _0284_ net36 sg13g2_a21oi_1
XFILLER_21_253 VPWR VGND sg13g2_decap_8
XFILLER_41_518 VPWR VGND sg13g2_decap_8
X_1049_ daisychain\[57\] net16 VPWR VGND sg13g2_buf_1
XFILLER_0_168 VPWR VGND sg13g2_decap_8
XFILLER_17_504 VPWR VGND sg13g2_decap_8
XFILLER_28_53 VPWR VGND sg13g2_decap_8
XFILLER_29_342 VPWR VGND sg13g2_decap_8
XFILLER_44_301 VPWR VGND sg13g2_decap_8
XFILLER_44_378 VPWR VGND sg13g2_decap_8
XFILLER_12_286 VPWR VGND sg13g2_decap_8
XFILLER_40_595 VPWR VGND sg13g2_decap_8
XFILLER_44_63 VPWR VGND sg13g2_decap_8
XFILLER_9_725 VPWR VGND sg13g2_decap_8
XFILLER_9_714 VPWR VGND sg13g2_fill_1
XFILLER_8_279 VPWR VGND sg13g2_decap_8
XFILLER_8_202 VPWR VGND sg13g2_decap_8
XFILLER_5_46 VPWR VGND sg13g2_decap_8
XFILLER_4_452 VPWR VGND sg13g2_decap_8
XFILLER_35_312 VPWR VGND sg13g2_decap_8
XFILLER_47_161 VPWR VGND sg13g2_decap_8
XFILLER_48_651 VPWR VGND sg13g2_decap_8
XFILLER_23_507 VPWR VGND sg13g2_decap_8
XFILLER_35_389 VPWR VGND sg13g2_decap_8
X_0618_ _0102_ _0373_ _0374_ net45 _0231_ VPWR VGND sg13g2_a22oi_1
X_0549_ VGND VPWR net26 daisychain\[20\] _0323_ net41 sg13g2_a21oi_1
XFILLER_26_323 VPWR VGND sg13g2_decap_8
XFILLER_39_684 VPWR VGND sg13g2_fill_1
XFILLER_41_315 VPWR VGND sg13g2_decap_8
XFILLER_14_55 VPWR VGND sg13g2_decap_8
XFILLER_22_573 VPWR VGND sg13g2_decap_8
XFILLER_30_32 VPWR VGND sg13g2_decap_8
XFILLER_5_249 VPWR VGND sg13g2_decap_8
XFILLER_17_301 VPWR VGND sg13g2_decap_8
XFILLER_1_455 VPWR VGND sg13g2_decap_8
XFILLER_39_63 VPWR VGND sg13g2_decap_8
XFILLER_49_459 VPWR VGND sg13g2_decap_8
XFILLER_17_378 VPWR VGND sg13g2_decap_8
XFILLER_32_337 VPWR VGND sg13g2_decap_8
XFILLER_44_175 VPWR VGND sg13g2_decap_8
XFILLER_45_665 VPWR VGND sg13g2_decap_8
XFILLER_45_676 VPWR VGND sg13g2_fill_1
XFILLER_13_595 VPWR VGND sg13g2_decap_8
XFILLER_40_392 VPWR VGND sg13g2_decap_8
XFILLER_9_544 VPWR VGND sg13g2_decap_8
XFILLER_23_304 VPWR VGND sg13g2_decap_8
XFILLER_35_186 VPWR VGND sg13g2_decap_8
XFILLER_25_43 VPWR VGND sg13g2_decap_8
XFILLER_26_120 VPWR VGND sg13g2_decap_8
XFILLER_26_197 VPWR VGND sg13g2_decap_8
XFILLER_27_665 VPWR VGND sg13g2_decap_8
XFILLER_27_698 VPWR VGND sg13g2_decap_8
XFILLER_41_112 VPWR VGND sg13g2_decap_8
XFILLER_42_602 VPWR VGND sg13g2_decap_8
XFILLER_42_679 VPWR VGND sg13g2_fill_1
Xclkbuf_5_2__f_clk clknet_5_2__leaf_clk clknet_4_1_0_clk VPWR VGND sg13g2_buf_16
XFILLER_10_510 VPWR VGND sg13g2_fill_2
XFILLER_22_370 VPWR VGND sg13g2_decap_8
XFILLER_41_189 VPWR VGND sg13g2_decap_8
XFILLER_41_42 VPWR VGND sg13g2_decap_8
XFILLER_1_252 VPWR VGND sg13g2_decap_8
XFILLER_2_25 VPWR VGND sg13g2_decap_8
XFILLER_2_764 VPWR VGND sg13g2_fill_1
XFILLER_18_610 VPWR VGND sg13g2_decap_8
XFILLER_45_462 VPWR VGND sg13g2_decap_8
XFILLER_49_256 VPWR VGND sg13g2_decap_8
XFILLER_17_175 VPWR VGND sg13g2_decap_8
XFILLER_32_134 VPWR VGND sg13g2_decap_8
X_0952_ net115 VGND VPWR _0112_ daisychain\[48\] clknet_5_31__leaf_clk sg13g2_dfrbpq_1
X_0883_ VPWR _0241_ daisychain\[48\] VGND sg13g2_inv_1
XFILLER_9_396 VPWR VGND sg13g2_decap_8
XFILLER_5_591 VPWR VGND sg13g2_fill_1
XFILLER_5_580 VPWR VGND sg13g2_decap_8
XFILLER_23_101 VPWR VGND sg13g2_decap_8
XFILLER_24_613 VPWR VGND sg13g2_decap_8
XFILLER_36_440 VPWR VGND sg13g2_decap_8
XFILLER_23_178 VPWR VGND sg13g2_decap_8
Xclkbuf_4_2_0_clk clknet_0_clk clknet_4_2_0_clk VPWR VGND sg13g2_buf_8
XFILLER_11_67 VPWR VGND sg13g2_decap_8
XFILLER_27_462 VPWR VGND sg13g2_decap_8
XFILLER_46_259 VPWR VGND sg13g2_decap_8
XFILLER_14_167 VPWR VGND sg13g2_decap_8
XFILLER_30_627 VPWR VGND sg13g2_decap_8
XFILLER_36_97 VPWR VGND sg13g2_decap_8
XFILLER_42_476 VPWR VGND sg13g2_decap_8
XFILLER_10_384 VPWR VGND sg13g2_decap_8
XFILLER_6_355 VPWR VGND sg13g2_decap_8
XFILLER_2_550 VPWR VGND sg13g2_decap_8
XFILLER_2_583 VPWR VGND sg13g2_fill_1
XFILLER_35_7 VPWR VGND sg13g2_fill_2
XFILLER_18_484 VPWR VGND sg13g2_decap_8
XFILLER_33_454 VPWR VGND sg13g2_decap_8
XFILLER_37_237 VPWR VGND sg13g2_decap_8
XFILLER_20_148 VPWR VGND sg13g2_decap_8
XFILLER_21_638 VPWR VGND sg13g2_decap_8
X_0866_ VPWR _0030_ state\[40\] VGND sg13g2_inv_1
X_0935_ net107 VGND VPWR _0095_ daisychain\[31\] clknet_5_23__leaf_clk sg13g2_dfrbpq_1
XFILLER_9_193 VPWR VGND sg13g2_decap_8
X_0797_ VPWR _0198_ daisychain\[5\] VGND sg13g2_inv_1
XFILLER_29_716 VPWR VGND sg13g2_fill_1
XFILLER_11_137 VPWR VGND sg13g2_decap_8
XFILLER_24_487 VPWR VGND sg13g2_decap_8
XFILLER_22_11 VPWR VGND sg13g2_fill_1
XFILLER_22_55 VPWR VGND sg13g2_decap_8
XFILLER_7_119 VPWR VGND sg13g2_decap_8
XFILLER_3_347 VPWR VGND sg13g2_decap_8
XFILLER_15_454 VPWR VGND sg13g2_decap_8
XFILLER_19_259 VPWR VGND sg13g2_decap_8
XFILLER_34_229 VPWR VGND sg13g2_decap_8
XFILLER_47_546 VPWR VGND sg13g2_decap_8
XFILLER_47_63 VPWR VGND sg13g2_decap_8
XFILLER_30_424 VPWR VGND sg13g2_decap_8
XFILLER_42_273 VPWR VGND sg13g2_decap_8
X_0720_ _0258_ VPWR _0128_ VGND net78 _0032_ sg13g2_o21ai_1
XFILLER_8_13 VPWR VGND sg13g2_decap_8
XFILLER_10_181 VPWR VGND sg13g2_decap_8
X_0651_ net92 VPWR _0399_ VGND net70 state\[47\] sg13g2_o21ai_1
X_0582_ _0093_ _0346_ _0347_ net44 _0222_ VPWR VGND sg13g2_a22oi_1
XFILLER_7_686 VPWR VGND sg13g2_decap_8
XFILLER_6_152 VPWR VGND sg13g2_decap_8
XFILLER_18_281 VPWR VGND sg13g2_decap_8
XFILLER_19_782 VPWR VGND sg13g2_decap_4
XFILLER_21_435 VPWR VGND sg13g2_decap_8
XFILLER_25_218 VPWR VGND sg13g2_decap_8
XFILLER_33_251 VPWR VGND sg13g2_decap_8
Xdigitalen.g\[0\].u.inv2 VPWR digitalen.g\[0\].u.OUTP digitalen.g\[0\].u.OUTN VGND
+ sg13g2_inv_1
X_0918_ net105 VGND VPWR _0078_ daisychain\[14\] clknet_5_3__leaf_clk sg13g2_dfrbpq_1
X_0849_ VPWR _0224_ daisychain\[31\] VGND sg13g2_inv_1
XFILLER_16_218 VPWR VGND sg13g2_decap_8
XFILLER_17_77 VPWR VGND sg13g2_decap_8
XFILLER_29_524 VPWR VGND sg13g2_decap_8
XFILLER_37_590 VPWR VGND sg13g2_decap_8
XFILLER_12_424 VPWR VGND sg13g2_decap_8
XFILLER_24_295 VPWR VGND sg13g2_decap_8
XFILLER_25_774 VPWR VGND sg13g2_fill_2
XFILLER_33_76 VPWR VGND sg13g2_decap_8
XFILLER_3_144 VPWR VGND sg13g2_decap_8
XFILLER_4_667 VPWR VGND sg13g2_fill_1
XFILLER_47_343 VPWR VGND sg13g2_decap_8
XFILLER_15_251 VPWR VGND sg13g2_decap_8
XFILLER_30_221 VPWR VGND sg13g2_decap_8
XFILLER_43_560 VPWR VGND sg13g2_decap_8
XFILLER_30_298 VPWR VGND sg13g2_decap_8
X_0703_ net77 VPWR _0438_ VGND net56 state\[60\] sg13g2_o21ai_1
XFILLER_7_483 VPWR VGND sg13g2_decap_8
X_0634_ _0106_ _0385_ _0386_ net49 _0235_ VPWR VGND sg13g2_a22oi_1
X_0565_ VGND VPWR net24 daisychain\[24\] _0335_ net36 sg13g2_a21oi_1
X_0496_ _0201_ net58 _0282_ _0283_ VPWR VGND sg13g2_a21o_1
XFILLER_26_505 VPWR VGND sg13g2_decap_8
XFILLER_38_321 VPWR VGND sg13g2_decap_8
XFILLER_38_398 VPWR VGND sg13g2_decap_8
XFILLER_0_91 VPWR VGND sg13g2_decap_8
XFILLER_21_232 VPWR VGND sg13g2_decap_8
XFILLER_34_593 VPWR VGND sg13g2_decap_8
X_1048_ daisychain\[56\] net15 VPWR VGND sg13g2_buf_1
XFILLER_0_147 VPWR VGND sg13g2_decap_8
XFILLER_28_32 VPWR VGND sg13g2_decap_8
XFILLER_29_321 VPWR VGND sg13g2_decap_8
XFILLER_25_582 VPWR VGND sg13g2_decap_8
XFILLER_29_398 VPWR VGND sg13g2_decap_8
XFILLER_32_519 VPWR VGND sg13g2_decap_8
XFILLER_44_357 VPWR VGND sg13g2_decap_8
XFILLER_44_42 VPWR VGND sg13g2_decap_8
XFILLER_12_265 VPWR VGND sg13g2_decap_8
XFILLER_40_574 VPWR VGND sg13g2_decap_8
XFILLER_8_258 VPWR VGND sg13g2_decap_8
XFILLER_5_25 VPWR VGND sg13g2_decap_8
XFILLER_4_431 VPWR VGND sg13g2_decap_8
XFILLER_47_140 VPWR VGND sg13g2_decap_8
XFILLER_48_630 VPWR VGND sg13g2_decap_8
XFILLER_16_582 VPWR VGND sg13g2_decap_8
XFILLER_31_585 VPWR VGND sg13g2_decap_8
XFILLER_35_368 VPWR VGND sg13g2_decap_8
XFILLER_7_280 VPWR VGND sg13g2_decap_8
X_0617_ VGND VPWR net29 daisychain\[37\] _0374_ net45 sg13g2_a21oi_1
X_0548_ _0214_ net64 _0321_ _0322_ VPWR VGND sg13g2_a21o_1
X_0479_ net79 VPWR _0270_ VGND net59 state\[4\] sg13g2_o21ai_1
XFILLER_26_302 VPWR VGND sg13g2_decap_8
XFILLER_26_379 VPWR VGND sg13g2_decap_8
XFILLER_38_195 VPWR VGND sg13g2_decap_8
XFILLER_14_34 VPWR VGND sg13g2_decap_8
XFILLER_22_552 VPWR VGND sg13g2_decap_8
XFILLER_34_390 VPWR VGND sg13g2_decap_8
XFILLER_5_228 VPWR VGND sg13g2_decap_8
XFILLER_1_434 VPWR VGND sg13g2_decap_8
XFILLER_30_88 VPWR VGND sg13g2_decap_8
XFILLER_39_42 VPWR VGND sg13g2_decap_8
XFILLER_29_195 VPWR VGND sg13g2_decap_8
XFILLER_45_644 VPWR VGND sg13g2_decap_8
XFILLER_49_438 VPWR VGND sg13g2_decap_8
XFILLER_13_574 VPWR VGND sg13g2_decap_8
XFILLER_17_357 VPWR VGND sg13g2_decap_8
XFILLER_32_316 VPWR VGND sg13g2_decap_8
XFILLER_40_371 VPWR VGND sg13g2_decap_8
XFILLER_44_154 VPWR VGND sg13g2_decap_8
XFILLER_9_501 VPWR VGND sg13g2_decap_8
XFILLER_24_817 VPWR VGND sg13g2_decap_4
XFILLER_35_165 VPWR VGND sg13g2_decap_8
XFILLER_36_655 VPWR VGND sg13g2_fill_1
XFILLER_31_382 VPWR VGND sg13g2_decap_8
XFILLER_27_644 VPWR VGND sg13g2_decap_8
XFILLER_14_349 VPWR VGND sg13g2_decap_8
XFILLER_15_806 VPWR VGND sg13g2_fill_1
XFILLER_15_817 VPWR VGND sg13g2_decap_4
XFILLER_25_99 VPWR VGND sg13g2_decap_8
XFILLER_26_176 VPWR VGND sg13g2_decap_8
XFILLER_41_168 VPWR VGND sg13g2_decap_8
XFILLER_10_566 VPWR VGND sg13g2_decap_4
XFILLER_10_588 VPWR VGND sg13g2_decap_8
XFILLER_41_21 VPWR VGND sg13g2_decap_8
XFILLER_41_98 VPWR VGND sg13g2_decap_8
XFILLER_6_537 VPWR VGND sg13g2_decap_8
XFILLER_1_231 VPWR VGND sg13g2_decap_8
XFILLER_49_235 VPWR VGND sg13g2_decap_8
XFILLER_17_154 VPWR VGND sg13g2_decap_8
XFILLER_32_113 VPWR VGND sg13g2_decap_8
XFILLER_37_419 VPWR VGND sg13g2_decap_8
XFILLER_45_441 VPWR VGND sg13g2_decap_8
XFILLER_13_360 VPWR VGND sg13g2_decap_8
XFILLER_41_680 VPWR VGND sg13g2_fill_2
X_0882_ VPWR _0007_ state\[48\] VGND sg13g2_inv_1
X_0951_ net113 VGND VPWR _0111_ daisychain\[47\] clknet_5_16__leaf_clk sg13g2_dfrbpq_1
XFILLER_9_375 VPWR VGND sg13g2_decap_8
XFILLER_11_319 VPWR VGND sg13g2_decap_8
XFILLER_23_157 VPWR VGND sg13g2_decap_8
XFILLER_24_669 VPWR VGND sg13g2_decap_8
XFILLER_36_496 VPWR VGND sg13g2_decap_8
XFILLER_11_46 VPWR VGND sg13g2_decap_8
XFILLER_20_820 VPWR VGND sg13g2_fill_2
XFILLER_3_529 VPWR VGND sg13g2_decap_8
XFILLER_27_441 VPWR VGND sg13g2_decap_8
XFILLER_36_43 VPWR VGND sg13g2_decap_4
XFILLER_36_76 VPWR VGND sg13g2_decap_8
XFILLER_46_238 VPWR VGND sg13g2_decap_8
XFILLER_47_728 VPWR VGND sg13g2_decap_8
XFILLER_14_146 VPWR VGND sg13g2_decap_8
XFILLER_23_691 VPWR VGND sg13g2_decap_4
XFILLER_30_606 VPWR VGND sg13g2_decap_8
XFILLER_42_455 VPWR VGND sg13g2_decap_8
XFILLER_10_363 VPWR VGND sg13g2_decap_8
XFILLER_6_334 VPWR VGND sg13g2_decap_8
XFILLER_2_595 VPWR VGND sg13g2_decap_4
XFILLER_37_216 VPWR VGND sg13g2_decap_8
XFILLER_18_463 VPWR VGND sg13g2_decap_8
XFILLER_21_617 VPWR VGND sg13g2_decap_8
XFILLER_33_433 VPWR VGND sg13g2_decap_8
XFILLER_20_127 VPWR VGND sg13g2_decap_8
X_0865_ VPWR _0232_ daisychain\[39\] VGND sg13g2_inv_1
X_0934_ net104 VGND VPWR _0094_ daisychain\[30\] clknet_5_23__leaf_clk sg13g2_dfrbpq_1
XFILLER_9_172 VPWR VGND sg13g2_decap_8
X_0796_ VPWR _0059_ state\[5\] VGND sg13g2_inv_1
XFILLER_24_400 VPWR VGND sg13g2_decap_8
XFILLER_24_411 VPWR VGND sg13g2_fill_2
XFILLER_28_249 VPWR VGND sg13g2_decap_8
XFILLER_11_116 VPWR VGND sg13g2_decap_8
XFILLER_22_34 VPWR VGND sg13g2_decap_8
XFILLER_24_466 VPWR VGND sg13g2_decap_8
XFILLER_36_293 VPWR VGND sg13g2_decap_8
XFILLER_20_694 VPWR VGND sg13g2_decap_4
XFILLER_3_326 VPWR VGND sg13g2_decap_8
XFILLER_19_238 VPWR VGND sg13g2_decap_8
XFILLER_47_42 VPWR VGND sg13g2_decap_8
XFILLER_47_525 VPWR VGND sg13g2_decap_8
XFILLER_15_433 VPWR VGND sg13g2_decap_8
XFILLER_30_403 VPWR VGND sg13g2_decap_8
XFILLER_34_208 VPWR VGND sg13g2_decap_8
XFILLER_42_252 VPWR VGND sg13g2_decap_8
XFILLER_10_160 VPWR VGND sg13g2_decap_8
XFILLER_11_650 VPWR VGND sg13g2_fill_1
XFILLER_8_69 VPWR VGND sg13g2_decap_8
XFILLER_6_131 VPWR VGND sg13g2_decap_8
Xdac0 digitalen.g\[1\].u.OUTP digitalen.g\[1\].u.OUTN digitalen.g\[2\].u.OUTP digitalen.g\[2\].u.OUTN
+ state\[16\] _0039_ state\[17\] _0040_ state\[18\] _0041_ state\[19\] _0042_ state\[20\]
+ _0044_ state\[21\] _0045_ state\[22\] _0046_ state\[23\] _0047_ state\[24\] _0048_
+ state\[25\] _0049_ state\[26\] _0050_ state\[27\] _0051_ state\[28\] _0052_ state\[29\]
+ _0053_ state\[30\] _0055_ state\[31\] _0056_ digitalen.g\[3\].u.OUTP digitalen.g\[3\].u.OUTN
+ state\[0\] _0032_ state\[1\] _0043_ state\[2\] _0054_ state\[3\] _0057_ state\[4\]
+ _0058_ state\[5\] _0059_ state\[6\] digitalen.g\[0\].u.OUTP digitalen.g\[0\].u.OUTN
+ _0060_ state\[7\] _0061_ state\[8\] _0062_ state\[9\] _0063_ state\[10\] _0033_
+ state\[11\] _0034_ state\[12\] _0035_ state\[13\] _0036_ state\[14\] _0037_ state\[15\]
+ _0038_ dac0/Iout dac0/VbiasP[0] dac0/VbiasP[1] dac0/VcascP[1] dac0/VcascP[0] VPWR
+ VGND dac32module
X_0650_ _0110_ _0397_ _0398_ net48 _0239_ VPWR VGND sg13g2_a22oi_1
X_0581_ VGND VPWR net24 daisychain\[28\] _0347_ net38 sg13g2_a21oi_1
XFILLER_18_260 VPWR VGND sg13g2_decap_8
XFILLER_26_4 VPWR VGND sg13g2_decap_8
XFILLER_38_536 VPWR VGND sg13g2_decap_4
Xclkbuf_4_1_0_clk clknet_0_clk clknet_4_1_0_clk VPWR VGND sg13g2_buf_8
XFILLER_21_414 VPWR VGND sg13g2_decap_8
XFILLER_33_230 VPWR VGND sg13g2_decap_8
X_0917_ net105 VGND VPWR _0077_ daisychain\[13\] clknet_5_1__leaf_clk sg13g2_dfrbpq_1
X_0848_ VPWR _0056_ state\[31\] VGND sg13g2_inv_1
X_0779_ _0436_ VPWR _0187_ VGND net97 _0019_ sg13g2_o21ai_1
XFILLER_0_329 VPWR VGND sg13g2_decap_8
XFILLER_29_503 VPWR VGND sg13g2_decap_8
XFILLER_12_403 VPWR VGND sg13g2_decap_8
XFILLER_17_56 VPWR VGND sg13g2_decap_8
XFILLER_44_539 VPWR VGND sg13g2_decap_8
XFILLER_20_491 VPWR VGND sg13g2_decap_8
XFILLER_24_274 VPWR VGND sg13g2_decap_8
XFILLER_25_797 VPWR VGND sg13g2_fill_2
XFILLER_33_55 VPWR VGND sg13g2_decap_8
XFILLER_3_123 VPWR VGND sg13g2_decap_8
XFILLER_47_322 VPWR VGND sg13g2_decap_8
XFILLER_48_812 VPWR VGND sg13g2_decap_8
XFILLER_15_230 VPWR VGND sg13g2_decap_8
XFILLER_16_775 VPWR VGND sg13g2_fill_1
XFILLER_30_200 VPWR VGND sg13g2_decap_8
XFILLER_47_399 VPWR VGND sg13g2_decap_8
XFILLER_30_277 VPWR VGND sg13g2_decap_8
X_0702_ _0123_ _0436_ _0437_ net34 _0252_ VPWR VGND sg13g2_a22oi_1
X_0633_ VGND VPWR net27 daisychain\[41\] _0386_ net49 sg13g2_a21oi_1
XFILLER_7_462 VPWR VGND sg13g2_decap_8
XFILLER_38_300 VPWR VGND sg13g2_decap_8
X_0564_ _0218_ net60 _0333_ _0334_ VPWR VGND sg13g2_a21o_1
X_0495_ net80 VPWR _0282_ VGND net58 state\[8\] sg13g2_o21ai_1
XFILLER_0_70 VPWR VGND sg13g2_decap_8
XFILLER_38_377 VPWR VGND sg13g2_decap_8
X_1047_ state\[63\] net14 VPWR VGND sg13g2_buf_1
XFILLER_21_211 VPWR VGND sg13g2_decap_8
XFILLER_21_288 VPWR VGND sg13g2_decap_8
XFILLER_34_572 VPWR VGND sg13g2_decap_8
XFILLER_0_126 VPWR VGND sg13g2_decap_8
XFILLER_28_11 VPWR VGND sg13g2_decap_8
XFILLER_28_88 VPWR VGND sg13g2_decap_8
XFILLER_29_300 VPWR VGND sg13g2_decap_8
XFILLER_29_377 VPWR VGND sg13g2_decap_8
XFILLER_48_119 VPWR VGND sg13g2_decap_8
XFILLER_12_244 VPWR VGND sg13g2_decap_8
XFILLER_17_539 VPWR VGND sg13g2_decap_8
XFILLER_25_561 VPWR VGND sg13g2_decap_8
XFILLER_40_553 VPWR VGND sg13g2_decap_8
XFILLER_44_21 VPWR VGND sg13g2_decap_8
XFILLER_44_336 VPWR VGND sg13g2_decap_8
XFILLER_44_98 VPWR VGND sg13g2_decap_8
XFILLER_8_237 VPWR VGND sg13g2_decap_8
XFILLER_4_410 VPWR VGND sg13g2_decap_8
XFILLER_39_119 VPWR VGND sg13g2_decap_8
XFILLER_4_487 VPWR VGND sg13g2_decap_8
XFILLER_16_561 VPWR VGND sg13g2_decap_8
XFILLER_35_347 VPWR VGND sg13g2_decap_8
XFILLER_47_196 VPWR VGND sg13g2_decap_8
XFILLER_48_686 VPWR VGND sg13g2_decap_8
XFILLER_31_564 VPWR VGND sg13g2_decap_8
X_0616_ _0231_ net71 _0372_ _0373_ VPWR VGND sg13g2_a21o_1
X_0547_ net86 VPWR _0321_ VGND net64 state\[21\] sg13g2_o21ai_1
X_0478_ _0067_ _0268_ _0269_ net35 _0196_ VPWR VGND sg13g2_a22oi_1
XFILLER_22_531 VPWR VGND sg13g2_decap_8
XFILLER_26_358 VPWR VGND sg13g2_decap_8
XFILLER_38_174 VPWR VGND sg13g2_decap_8
XFILLER_39_697 VPWR VGND sg13g2_fill_1
XFILLER_42_807 VPWR VGND sg13g2_fill_1
XFILLER_42_818 VPWR VGND sg13g2_decap_4
XFILLER_5_207 VPWR VGND sg13g2_decap_8
XFILLER_1_413 VPWR VGND sg13g2_decap_8
XFILLER_30_67 VPWR VGND sg13g2_decap_8
XFILLER_39_21 VPWR VGND sg13g2_decap_8
XFILLER_49_417 VPWR VGND sg13g2_decap_8
XFILLER_17_336 VPWR VGND sg13g2_decap_8
XFILLER_18_804 VPWR VGND sg13g2_fill_1
XFILLER_18_815 VPWR VGND sg13g2_decap_8
XFILLER_29_174 VPWR VGND sg13g2_decap_8
XFILLER_39_98 VPWR VGND sg13g2_decap_8
XFILLER_44_133 VPWR VGND sg13g2_decap_8
XFILLER_45_623 VPWR VGND sg13g2_decap_8
XFILLER_13_553 VPWR VGND sg13g2_decap_8
XFILLER_40_350 VPWR VGND sg13g2_decap_8
XFILLER_4_284 VPWR VGND sg13g2_decap_8
XFILLER_0_490 VPWR VGND sg13g2_decap_8
Xclkbuf_5_27__f_clk clknet_5_27__leaf_clk clknet_4_13_0_clk VPWR VGND sg13g2_buf_16
XFILLER_23_339 VPWR VGND sg13g2_decap_8
XFILLER_35_144 VPWR VGND sg13g2_decap_8
XFILLER_48_483 VPWR VGND sg13g2_decap_8
XFILLER_31_361 VPWR VGND sg13g2_decap_8
XFILLER_26_155 VPWR VGND sg13g2_decap_8
XFILLER_27_623 VPWR VGND sg13g2_decap_8
XFILLER_27_678 VPWR VGND sg13g2_decap_8
XFILLER_10_512 VPWR VGND sg13g2_fill_1
XFILLER_14_328 VPWR VGND sg13g2_decap_8
XFILLER_25_78 VPWR VGND sg13g2_decap_8
XFILLER_41_147 VPWR VGND sg13g2_decap_8
XFILLER_42_637 VPWR VGND sg13g2_decap_8
XFILLER_42_648 VPWR VGND sg13g2_fill_2
XFILLER_10_545 VPWR VGND sg13g2_decap_8
XFILLER_1_210 VPWR VGND sg13g2_decap_8
XFILLER_41_77 VPWR VGND sg13g2_decap_8
XFILLER_6_516 VPWR VGND sg13g2_decap_8
XFILLER_1_287 VPWR VGND sg13g2_decap_8
XFILLER_2_777 VPWR VGND sg13g2_decap_8
XFILLER_2_788 VPWR VGND sg13g2_fill_1
XFILLER_49_214 VPWR VGND sg13g2_decap_8
XFILLER_17_133 VPWR VGND sg13g2_decap_8
XFILLER_18_645 VPWR VGND sg13g2_decap_8
XFILLER_33_615 VPWR VGND sg13g2_decap_8
XFILLER_45_420 VPWR VGND sg13g2_decap_8
XFILLER_45_497 VPWR VGND sg13g2_decap_8
XFILLER_20_309 VPWR VGND sg13g2_decap_8
XFILLER_32_169 VPWR VGND sg13g2_decap_8
X_0881_ VPWR _0240_ daisychain\[47\] VGND sg13g2_inv_1
X_0950_ net113 VGND VPWR _0110_ daisychain\[46\] clknet_5_17__leaf_clk sg13g2_dfrbpq_1
XFILLER_9_354 VPWR VGND sg13g2_decap_8
XFILLER_49_781 VPWR VGND sg13g2_decap_8
XFILLER_48_280 VPWR VGND sg13g2_decap_8
XFILLER_23_136 VPWR VGND sg13g2_decap_8
XFILLER_24_648 VPWR VGND sg13g2_decap_8
XFILLER_32_681 VPWR VGND sg13g2_fill_2
XFILLER_36_475 VPWR VGND sg13g2_decap_8
XFILLER_11_25 VPWR VGND sg13g2_decap_8
XFILLER_3_508 VPWR VGND sg13g2_decap_8
XFILLER_47_707 VPWR VGND sg13g2_decap_8
Xclkbuf_5_10__f_clk clknet_5_10__leaf_clk clknet_4_5_0_clk VPWR VGND sg13g2_buf_16
XFILLER_14_125 VPWR VGND sg13g2_decap_8
XFILLER_15_615 VPWR VGND sg13g2_fill_2
XFILLER_27_420 VPWR VGND sg13g2_decap_8
XFILLER_27_497 VPWR VGND sg13g2_decap_8
XFILLER_39_280 VPWR VGND sg13g2_decap_8
XFILLER_42_434 VPWR VGND sg13g2_decap_8
XFILLER_46_217 VPWR VGND sg13g2_decap_8
XFILLER_10_342 VPWR VGND sg13g2_decap_8
XFILLER_23_670 VPWR VGND sg13g2_fill_1
XFILLER_6_313 VPWR VGND sg13g2_decap_8
XFILLER_2_574 VPWR VGND sg13g2_decap_8
XFILLER_18_442 VPWR VGND sg13g2_decap_8
XFILLER_20_106 VPWR VGND sg13g2_decap_8
XFILLER_33_412 VPWR VGND sg13g2_decap_8
XFILLER_33_489 VPWR VGND sg13g2_decap_8
XFILLER_45_294 VPWR VGND sg13g2_decap_8
XFILLER_46_773 VPWR VGND sg13g2_decap_4
X_0864_ VPWR _0029_ state\[39\] VGND sg13g2_inv_1
X_0933_ net104 VGND VPWR _0093_ daisychain\[29\] clknet_5_6__leaf_clk sg13g2_dfrbpq_1
X_0795_ VPWR _0197_ daisychain\[4\] VGND sg13g2_inv_1
XFILLER_9_151 VPWR VGND sg13g2_decap_8
XFILLER_3_81 VPWR VGND sg13g2_decap_8
XFILLER_47_0 VPWR VGND sg13g2_decap_8
XFILLER_24_445 VPWR VGND sg13g2_decap_8
XFILLER_28_228 VPWR VGND sg13g2_decap_8
XFILLER_36_272 VPWR VGND sg13g2_decap_8
XFILLER_20_673 VPWR VGND sg13g2_decap_8
XFILLER_3_305 VPWR VGND sg13g2_decap_8
XFILLER_19_217 VPWR VGND sg13g2_decap_8
XFILLER_47_21 VPWR VGND sg13g2_decap_8
XFILLER_47_504 VPWR VGND sg13g2_decap_8
XFILLER_47_98 VPWR VGND sg13g2_decap_8
XFILLER_15_412 VPWR VGND sg13g2_decap_8
XFILLER_15_489 VPWR VGND sg13g2_decap_8
XFILLER_27_294 VPWR VGND sg13g2_decap_8
XFILLER_42_231 VPWR VGND sg13g2_decap_8
XFILLER_12_90 VPWR VGND sg13g2_decap_8
XFILLER_30_459 VPWR VGND sg13g2_decap_8
Xdac1 digitalen.g\[1\].u.OUTP digitalen.g\[1\].u.OUTN digitalen.g\[2\].u.OUTP digitalen.g\[2\].u.OUTN
+ state\[48\] _0007_ state\[49\] _0008_ state\[50\] _0009_ state\[51\] _0010_ state\[52\]
+ _0012_ state\[53\] _0013_ state\[54\] _0014_ state\[55\] _0015_ state\[56\] _0016_
+ state\[57\] _0017_ state\[58\] _0018_ state\[59\] _0019_ state\[60\] _0020_ state\[61\]
+ _0021_ state\[62\] _0023_ state\[63\] _0024_ digitalen.g\[3\].u.OUTP digitalen.g\[3\].u.OUTN
+ state\[32\] _0000_ state\[33\] _0011_ state\[34\] _0022_ state\[35\] _0025_ state\[36\]
+ _0026_ state\[37\] _0027_ state\[38\] digitalen.g\[0\].u.OUTP digitalen.g\[0\].u.OUTN
+ _0028_ state\[39\] _0029_ state\[40\] _0030_ state\[41\] _0031_ state\[42\] _0001_
+ state\[43\] _0002_ state\[44\] _0003_ state\[45\] _0004_ state\[46\] _0005_ state\[47\]
+ _0006_ dac1/Iout dac1/VbiasP[0] dac1/VbiasP[1] dac1/VcascP[1] dac1/VcascP[0] VPWR
+ VGND dac32module
XFILLER_8_48 VPWR VGND sg13g2_decap_8
XFILLER_6_110 VPWR VGND sg13g2_decap_8
XFILLER_2_382 VPWR VGND sg13g2_decap_8
XFILLER_40_7 VPWR VGND sg13g2_decap_8
X_0580_ _0222_ net66 _0345_ _0346_ VPWR VGND sg13g2_a21o_1
XFILLER_6_187 VPWR VGND sg13g2_decap_8
XFILLER_19_4 VPWR VGND sg13g2_decap_4
XFILLER_38_515 VPWR VGND sg13g2_decap_8
XFILLER_46_581 VPWR VGND sg13g2_decap_8
XFILLER_33_286 VPWR VGND sg13g2_decap_8
X_0916_ net102 VGND VPWR _0076_ daisychain\[12\] clknet_5_3__leaf_clk sg13g2_dfrbpq_1
XFILLER_0_308 VPWR VGND sg13g2_decap_8
X_0847_ VPWR _0223_ daisychain\[30\] VGND sg13g2_inv_1
X_0778_ _0433_ VPWR _0186_ VGND net97 _0018_ sg13g2_o21ai_1
XFILLER_17_13 VPWR VGND sg13g2_decap_4
XFILLER_29_559 VPWR VGND sg13g2_decap_8
XFILLER_24_253 VPWR VGND sg13g2_decap_8
XFILLER_25_776 VPWR VGND sg13g2_fill_1
XFILLER_33_34 VPWR VGND sg13g2_decap_8
XFILLER_44_518 VPWR VGND sg13g2_decap_8
XFILLER_12_459 VPWR VGND sg13g2_decap_8
XFILLER_20_470 VPWR VGND sg13g2_decap_8
XFILLER_3_102 VPWR VGND sg13g2_decap_8
XFILLER_8_419 VPWR VGND sg13g2_decap_8
XFILLER_3_179 VPWR VGND sg13g2_decap_8
Xclkbuf_5_8__f_clk clknet_5_8__leaf_clk clknet_4_4_0_clk VPWR VGND sg13g2_buf_16
XFILLER_28_592 VPWR VGND sg13g2_decap_8
XFILLER_35_529 VPWR VGND sg13g2_decap_8
XFILLER_47_301 VPWR VGND sg13g2_decap_8
XFILLER_47_378 VPWR VGND sg13g2_decap_8
XFILLER_15_286 VPWR VGND sg13g2_decap_8
XFILLER_30_256 VPWR VGND sg13g2_decap_8
XFILLER_43_595 VPWR VGND sg13g2_decap_8
X_0701_ VGND VPWR net32 daisychain\[58\] _0437_ net34 sg13g2_a21oi_1
X_0632_ _0235_ net69 _0384_ _0385_ VPWR VGND sg13g2_a21o_1
X_0563_ net80 VPWR _0333_ VGND net58 state\[25\] sg13g2_o21ai_1
XFILLER_7_441 VPWR VGND sg13g2_decap_8
X_0494_ _0071_ _0280_ _0281_ net37 _0200_ VPWR VGND sg13g2_a22oi_1
XFILLER_19_581 VPWR VGND sg13g2_decap_8
XFILLER_34_551 VPWR VGND sg13g2_decap_8
XFILLER_38_356 VPWR VGND sg13g2_decap_8
X_1046_ state\[62\] net13 VPWR VGND sg13g2_buf_1
XFILLER_21_267 VPWR VGND sg13g2_decap_8
XFILLER_30_790 VPWR VGND sg13g2_fill_2
XFILLER_0_105 VPWR VGND sg13g2_decap_8
XFILLER_17_518 VPWR VGND sg13g2_decap_8
XFILLER_28_67 VPWR VGND sg13g2_decap_8
XFILLER_29_356 VPWR VGND sg13g2_decap_8
XFILLER_44_315 VPWR VGND sg13g2_decap_8
XFILLER_12_223 VPWR VGND sg13g2_decap_8
XFILLER_13_735 VPWR VGND sg13g2_fill_2
XFILLER_25_540 VPWR VGND sg13g2_decap_8
XFILLER_40_532 VPWR VGND sg13g2_decap_8
XFILLER_44_77 VPWR VGND sg13g2_decap_8
XFILLER_9_739 VPWR VGND sg13g2_decap_4
XFILLER_8_216 VPWR VGND sg13g2_decap_8
Xclkbuf_4_0_0_clk clknet_0_clk clknet_4_0_0_clk VPWR VGND sg13g2_buf_8
XFILLER_4_466 VPWR VGND sg13g2_decap_8
XFILLER_0_672 VPWR VGND sg13g2_decap_8
XFILLER_10_8 VPWR VGND sg13g2_fill_1
XFILLER_16_540 VPWR VGND sg13g2_decap_8
XFILLER_35_326 VPWR VGND sg13g2_decap_8
XFILLER_47_175 VPWR VGND sg13g2_decap_8
XFILLER_48_665 VPWR VGND sg13g2_decap_8
XFILLER_31_543 VPWR VGND sg13g2_decap_8
XFILLER_43_392 VPWR VGND sg13g2_decap_8
X_0615_ net93 VPWR _0372_ VGND net71 state\[38\] sg13g2_o21ai_1
X_0546_ _0084_ _0319_ _0320_ net41 _0213_ VPWR VGND sg13g2_a22oi_1
XFILLER_26_337 VPWR VGND sg13g2_decap_8
XFILLER_27_805 VPWR VGND sg13g2_fill_1
XFILLER_27_816 VPWR VGND sg13g2_decap_8
XFILLER_38_153 VPWR VGND sg13g2_decap_8
XFILLER_39_665 VPWR VGND sg13g2_fill_2
X_0477_ VGND VPWR net31 daisychain\[2\] _0269_ net35 sg13g2_a21oi_1
XFILLER_14_69 VPWR VGND sg13g2_decap_8
XFILLER_22_510 VPWR VGND sg13g2_decap_8
XFILLER_22_587 VPWR VGND sg13g2_decap_8
XFILLER_41_329 VPWR VGND sg13g2_decap_8
X_1029_ net98 VGND VPWR _0189_ state\[61\] clknet_5_10__leaf_clk sg13g2_dfrbpq_1
XFILLER_30_46 VPWR VGND sg13g2_decap_8
XFILLER_1_469 VPWR VGND sg13g2_decap_8
XFILLER_39_77 VPWR VGND sg13g2_decap_8
XFILLER_17_315 VPWR VGND sg13g2_decap_8
XFILLER_29_153 VPWR VGND sg13g2_decap_8
XFILLER_44_112 VPWR VGND sg13g2_decap_8
XFILLER_44_189 VPWR VGND sg13g2_decap_8
XFILLER_45_602 VPWR VGND sg13g2_decap_8
XFILLER_13_532 VPWR VGND sg13g2_decap_8
XFILLER_9_558 VPWR VGND sg13g2_decap_8
XFILLER_4_263 VPWR VGND sg13g2_decap_8
XFILLER_48_462 VPWR VGND sg13g2_decap_8
XFILLER_23_318 VPWR VGND sg13g2_decap_8
XFILLER_31_340 VPWR VGND sg13g2_decap_8
XFILLER_35_123 VPWR VGND sg13g2_decap_8
X_0529_ VGND VPWR net25 daisychain\[15\] _0308_ net40 sg13g2_a21oi_1
XFILLER_14_307 VPWR VGND sg13g2_decap_8
XFILLER_26_134 VPWR VGND sg13g2_decap_8
XFILLER_27_602 VPWR VGND sg13g2_decap_8
XFILLER_39_462 VPWR VGND sg13g2_decap_8
XFILLER_42_616 VPWR VGND sg13g2_decap_8
XFILLER_22_384 VPWR VGND sg13g2_decap_8
XFILLER_25_57 VPWR VGND sg13g2_decap_8
XFILLER_35_690 VPWR VGND sg13g2_decap_8
XFILLER_41_126 VPWR VGND sg13g2_decap_8
XFILLER_41_56 VPWR VGND sg13g2_decap_8
XFILLER_17_112 VPWR VGND sg13g2_decap_8
XFILLER_18_624 VPWR VGND sg13g2_decap_8
XFILLER_1_266 VPWR VGND sg13g2_decap_8
XFILLER_2_39 VPWR VGND sg13g2_decap_8
XFILLER_17_189 VPWR VGND sg13g2_decap_8
XFILLER_32_148 VPWR VGND sg13g2_decap_8
XFILLER_45_476 VPWR VGND sg13g2_decap_8
XFILLER_15_90 VPWR VGND sg13g2_decap_8
X_0880_ VPWR _0006_ state\[47\] VGND sg13g2_inv_1
XFILLER_9_333 VPWR VGND sg13g2_decap_8
XFILLER_49_4 VPWR VGND sg13g2_decap_8
XFILLER_24_627 VPWR VGND sg13g2_decap_8
XFILLER_36_454 VPWR VGND sg13g2_decap_8
XFILLER_49_760 VPWR VGND sg13g2_decap_8
XFILLER_20_822 VPWR VGND sg13g2_fill_1
XFILLER_23_115 VPWR VGND sg13g2_decap_8
XFILLER_32_671 VPWR VGND sg13g2_fill_1
Xdigitalen.g\[3\].u.inv1 VPWR digitalen.g\[3\].u.OUTN net6 VGND sg13g2_inv_1
XFILLER_14_104 VPWR VGND sg13g2_decap_8
XFILLER_27_476 VPWR VGND sg13g2_decap_8
XFILLER_42_413 VPWR VGND sg13g2_decap_8
XFILLER_10_321 VPWR VGND sg13g2_decap_8
XFILLER_10_398 VPWR VGND sg13g2_decap_8
XFILLER_22_181 VPWR VGND sg13g2_decap_8
XFILLER_6_369 VPWR VGND sg13g2_decap_8
XFILLER_2_564 VPWR VGND sg13g2_decap_4
XFILLER_7_0 VPWR VGND sg13g2_decap_8
XFILLER_18_421 VPWR VGND sg13g2_decap_8
XFILLER_46_730 VPWR VGND sg13g2_decap_4
XFILLER_13_192 VPWR VGND sg13g2_decap_8
XFILLER_18_498 VPWR VGND sg13g2_decap_8
XFILLER_33_468 VPWR VGND sg13g2_decap_8
XFILLER_41_490 VPWR VGND sg13g2_decap_8
XFILLER_45_273 VPWR VGND sg13g2_decap_8
X_0932_ net104 VGND VPWR _0092_ daisychain\[28\] clknet_5_14__leaf_clk sg13g2_dfrbpq_1
XFILLER_9_130 VPWR VGND sg13g2_decap_8
X_0863_ VPWR _0231_ daisychain\[38\] VGND sg13g2_inv_1
X_0794_ VPWR _0058_ state\[4\] VGND sg13g2_inv_1
XFILLER_28_207 VPWR VGND sg13g2_decap_8
XFILLER_3_60 VPWR VGND sg13g2_decap_8
XFILLER_36_251 VPWR VGND sg13g2_decap_8
XFILLER_20_652 VPWR VGND sg13g2_decap_8
XFILLER_22_69 VPWR VGND sg13g2_decap_8
XFILLER_0_7 VPWR VGND sg13g2_decap_8
XFILLER_43_700 VPWR VGND sg13g2_fill_1
XFILLER_47_77 VPWR VGND sg13g2_decap_8
XFILLER_15_468 VPWR VGND sg13g2_decap_8
XFILLER_27_273 VPWR VGND sg13g2_decap_8
XFILLER_30_438 VPWR VGND sg13g2_decap_8
XFILLER_42_210 VPWR VGND sg13g2_decap_8
XFILLER_42_287 VPWR VGND sg13g2_decap_8
XFILLER_8_27 VPWR VGND sg13g2_decap_8
XFILLER_10_195 VPWR VGND sg13g2_decap_8
XFILLER_11_685 VPWR VGND sg13g2_fill_2
XFILLER_7_612 VPWR VGND sg13g2_decap_8
XFILLER_6_166 VPWR VGND sg13g2_decap_8
XFILLER_2_361 VPWR VGND sg13g2_decap_8
XFILLER_18_295 VPWR VGND sg13g2_decap_8
XFILLER_46_560 VPWR VGND sg13g2_decap_8
XFILLER_21_449 VPWR VGND sg13g2_decap_8
XFILLER_33_265 VPWR VGND sg13g2_decap_8
X_0915_ net102 VGND VPWR _0075_ daisychain\[11\] clknet_5_2__leaf_clk sg13g2_dfrbpq_1
X_0846_ VPWR _0055_ state\[30\] VGND sg13g2_inv_1
X_0777_ _0430_ VPWR _0185_ VGND net97 _0017_ sg13g2_o21ai_1
XFILLER_29_538 VPWR VGND sg13g2_decap_8
XFILLER_12_438 VPWR VGND sg13g2_decap_8
XFILLER_24_232 VPWR VGND sg13g2_decap_8
XFILLER_25_722 VPWR VGND sg13g2_decap_4
XFILLER_3_158 VPWR VGND sg13g2_decap_8
XFILLER_28_571 VPWR VGND sg13g2_decap_8
XFILLER_35_508 VPWR VGND sg13g2_decap_8
XFILLER_47_357 VPWR VGND sg13g2_decap_8
XFILLER_11_493 VPWR VGND sg13g2_decap_8
XFILLER_15_265 VPWR VGND sg13g2_decap_8
XFILLER_30_235 VPWR VGND sg13g2_decap_8
XFILLER_43_574 VPWR VGND sg13g2_decap_8
X_0700_ _0252_ net56 _0435_ _0436_ VPWR VGND sg13g2_a21o_1
XFILLER_7_420 VPWR VGND sg13g2_decap_8
X_0631_ net91 VPWR _0384_ VGND net69 state\[42\] sg13g2_o21ai_1
X_0562_ _0088_ _0331_ _0332_ net39 _0217_ VPWR VGND sg13g2_a22oi_1
XFILLER_7_497 VPWR VGND sg13g2_decap_8
XFILLER_19_560 VPWR VGND sg13g2_decap_8
XFILLER_26_519 VPWR VGND sg13g2_decap_8
XFILLER_31_4 VPWR VGND sg13g2_decap_8
XFILLER_38_335 VPWR VGND sg13g2_decap_8
X_0493_ VGND VPWR net23 daisychain\[6\] _0281_ net37 sg13g2_a21oi_1
XFILLER_21_246 VPWR VGND sg13g2_decap_8
XFILLER_34_530 VPWR VGND sg13g2_decap_8
X_1045_ state\[61\] net12 VPWR VGND sg13g2_buf_1
X_0829_ VPWR _0214_ daisychain\[21\] VGND sg13g2_inv_1
XFILLER_9_81 VPWR VGND sg13g2_decap_8
XFILLER_28_46 VPWR VGND sg13g2_decap_8
XFILLER_29_335 VPWR VGND sg13g2_decap_8
XFILLER_12_202 VPWR VGND sg13g2_decap_8
XFILLER_12_279 VPWR VGND sg13g2_decap_8
XFILLER_25_596 VPWR VGND sg13g2_decap_8
XFILLER_40_511 VPWR VGND sg13g2_decap_8
XFILLER_40_588 VPWR VGND sg13g2_decap_8
XFILLER_44_56 VPWR VGND sg13g2_decap_8
XFILLER_5_39 VPWR VGND sg13g2_decap_8
XFILLER_4_445 VPWR VGND sg13g2_decap_8
XFILLER_35_305 VPWR VGND sg13g2_decap_8
XFILLER_47_154 VPWR VGND sg13g2_decap_8
XFILLER_48_644 VPWR VGND sg13g2_decap_8
XFILLER_16_596 VPWR VGND sg13g2_decap_8
XFILLER_31_522 VPWR VGND sg13g2_decap_8
XFILLER_43_371 VPWR VGND sg13g2_decap_8
XFILLER_31_599 VPWR VGND sg13g2_decap_8
X_0614_ _0101_ _0370_ _0371_ net45 _0230_ VPWR VGND sg13g2_a22oi_1
X_0545_ VGND VPWR net26 daisychain\[19\] _0320_ net41 sg13g2_a21oi_1
X_0476_ _0196_ net57 _0267_ _0268_ VPWR VGND sg13g2_a21o_1
XFILLER_7_294 VPWR VGND sg13g2_decap_8
XFILLER_26_316 VPWR VGND sg13g2_decap_8
XFILLER_38_132 VPWR VGND sg13g2_decap_8
XFILLER_39_677 VPWR VGND sg13g2_decap_8
XFILLER_14_48 VPWR VGND sg13g2_decap_8
XFILLER_22_566 VPWR VGND sg13g2_decap_8
XFILLER_41_308 VPWR VGND sg13g2_decap_8
X_1028_ net109 VGND VPWR _0188_ state\[60\] clknet_5_22__leaf_clk sg13g2_dfrbpq_1
XFILLER_30_25 VPWR VGND sg13g2_decap_8
XFILLER_1_448 VPWR VGND sg13g2_decap_8
XFILLER_29_132 VPWR VGND sg13g2_decap_8
XFILLER_39_56 VPWR VGND sg13g2_decap_8
XFILLER_13_511 VPWR VGND sg13g2_decap_8
XFILLER_25_393 VPWR VGND sg13g2_decap_8
XFILLER_44_168 VPWR VGND sg13g2_decap_8
XFILLER_45_658 VPWR VGND sg13g2_decap_8
XFILLER_13_588 VPWR VGND sg13g2_decap_8
XFILLER_40_385 VPWR VGND sg13g2_decap_8
XFILLER_9_537 VPWR VGND sg13g2_decap_8
XFILLER_5_710 VPWR VGND sg13g2_fill_1
XFILLER_4_242 VPWR VGND sg13g2_decap_8
XFILLER_35_102 VPWR VGND sg13g2_decap_8
XFILLER_48_441 VPWR VGND sg13g2_decap_8
XFILLER_16_393 VPWR VGND sg13g2_decap_8
XFILLER_31_396 VPWR VGND sg13g2_decap_8
XFILLER_35_179 VPWR VGND sg13g2_decap_8
XFILLER_6_82 VPWR VGND sg13g2_decap_8
XFILLER_39_441 VPWR VGND sg13g2_decap_8
X_0528_ _0209_ net63 _0306_ _0307_ VPWR VGND sg13g2_a21o_1
X_0459_ VPWR _0255_ daisychain\[62\] VGND sg13g2_inv_1
XFILLER_25_36 VPWR VGND sg13g2_decap_8
XFILLER_26_113 VPWR VGND sg13g2_decap_8
XFILLER_27_658 VPWR VGND sg13g2_decap_8
XFILLER_41_105 VPWR VGND sg13g2_decap_8
XFILLER_10_503 VPWR VGND sg13g2_decap_8
XFILLER_22_363 VPWR VGND sg13g2_decap_8
XFILLER_41_35 VPWR VGND sg13g2_decap_8
XFILLER_1_245 VPWR VGND sg13g2_decap_8
XFILLER_2_713 VPWR VGND sg13g2_fill_2
XFILLER_9_4 VPWR VGND sg13g2_decap_8
XFILLER_18_603 VPWR VGND sg13g2_decap_8
XFILLER_2_18 VPWR VGND sg13g2_decap_8
XFILLER_45_455 VPWR VGND sg13g2_decap_8
XFILLER_49_249 VPWR VGND sg13g2_decap_8
XFILLER_13_374 VPWR VGND sg13g2_decap_8
XFILLER_17_168 VPWR VGND sg13g2_decap_8
XFILLER_25_190 VPWR VGND sg13g2_decap_8
XFILLER_32_127 VPWR VGND sg13g2_decap_8
XFILLER_41_694 VPWR VGND sg13g2_fill_2
XFILLER_9_312 VPWR VGND sg13g2_decap_8
XFILLER_40_182 VPWR VGND sg13g2_decap_8
XFILLER_9_389 VPWR VGND sg13g2_decap_8
XFILLER_5_573 VPWR VGND sg13g2_decap_8
XFILLER_5_540 VPWR VGND sg13g2_fill_1
XFILLER_17_691 VPWR VGND sg13g2_decap_4
XFILLER_24_606 VPWR VGND sg13g2_decap_8
XFILLER_36_433 VPWR VGND sg13g2_decap_8
XFILLER_16_190 VPWR VGND sg13g2_decap_8
XFILLER_31_193 VPWR VGND sg13g2_decap_8
Xdigitalen.g\[3\].u.inv2 VPWR digitalen.g\[3\].u.OUTP digitalen.g\[3\].u.OUTN VGND
+ sg13g2_inv_1
XFILLER_10_300 VPWR VGND sg13g2_decap_8
XFILLER_22_160 VPWR VGND sg13g2_decap_8
XFILLER_23_661 VPWR VGND sg13g2_decap_8
XFILLER_27_455 VPWR VGND sg13g2_decap_8
XFILLER_42_469 VPWR VGND sg13g2_decap_8
XFILLER_10_377 VPWR VGND sg13g2_decap_8
XFILLER_6_348 VPWR VGND sg13g2_decap_8
XFILLER_2_543 VPWR VGND sg13g2_decap_8
XFILLER_2_587 VPWR VGND sg13g2_fill_2
XFILLER_18_400 VPWR VGND sg13g2_decap_8
XFILLER_18_477 VPWR VGND sg13g2_decap_8
XFILLER_45_252 VPWR VGND sg13g2_decap_8
XFILLER_13_171 VPWR VGND sg13g2_decap_8
XFILLER_33_447 VPWR VGND sg13g2_decap_8
X_0862_ VPWR _0028_ state\[38\] VGND sg13g2_inv_1
X_0931_ net104 VGND VPWR _0091_ daisychain\[27\] clknet_5_14__leaf_clk sg13g2_dfrbpq_1
X_0793_ VPWR _0196_ daisychain\[3\] VGND sg13g2_inv_1
XFILLER_9_186 VPWR VGND sg13g2_decap_8
XFILLER_36_230 VPWR VGND sg13g2_decap_8
XFILLER_20_631 VPWR VGND sg13g2_decap_8
XFILLER_22_48 VPWR VGND sg13g2_decap_8
XFILLER_32_491 VPWR VGND sg13g2_decap_8
Xfanout110 net112 net110 VPWR VGND sg13g2_buf_1
XFILLER_27_252 VPWR VGND sg13g2_decap_8
XFILLER_28_797 VPWR VGND sg13g2_fill_2
XFILLER_43_712 VPWR VGND sg13g2_decap_4
XFILLER_47_539 VPWR VGND sg13g2_decap_8
XFILLER_47_56 VPWR VGND sg13g2_decap_8
XFILLER_15_447 VPWR VGND sg13g2_decap_8
XFILLER_30_417 VPWR VGND sg13g2_decap_8
XFILLER_42_266 VPWR VGND sg13g2_decap_8
XFILLER_7_602 VPWR VGND sg13g2_fill_1
XFILLER_10_174 VPWR VGND sg13g2_decap_8
XFILLER_2_340 VPWR VGND sg13g2_decap_8
XFILLER_7_679 VPWR VGND sg13g2_decap_8
XFILLER_6_145 VPWR VGND sg13g2_decap_8
XFILLER_18_274 VPWR VGND sg13g2_decap_8
XFILLER_19_786 VPWR VGND sg13g2_fill_1
XFILLER_21_428 VPWR VGND sg13g2_decap_8
XFILLER_33_244 VPWR VGND sg13g2_decap_8
X_0914_ net102 VGND VPWR _0074_ daisychain\[10\] clknet_5_2__leaf_clk sg13g2_dfrbpq_1
X_0845_ VPWR _0222_ daisychain\[29\] VGND sg13g2_inv_1
X_0776_ _0427_ VPWR _0184_ VGND net90 _0016_ sg13g2_o21ai_1
XFILLER_24_211 VPWR VGND sg13g2_decap_8
XFILLER_29_517 VPWR VGND sg13g2_decap_8
XFILLER_37_550 VPWR VGND sg13g2_decap_8
XFILLER_37_561 VPWR VGND sg13g2_fill_2
XFILLER_37_583 VPWR VGND sg13g2_decap_8
XFILLER_12_417 VPWR VGND sg13g2_decap_8
XFILLER_24_288 VPWR VGND sg13g2_decap_8
XFILLER_25_767 VPWR VGND sg13g2_decap_4
XFILLER_33_69 VPWR VGND sg13g2_decap_8
XFILLER_3_137 VPWR VGND sg13g2_decap_8
XFILLER_0_822 VPWR VGND sg13g2_fill_1
XFILLER_47_336 VPWR VGND sg13g2_decap_8
XFILLER_15_244 VPWR VGND sg13g2_decap_8
XFILLER_28_550 VPWR VGND sg13g2_decap_8
XFILLER_43_553 VPWR VGND sg13g2_decap_8
XFILLER_11_461 VPWR VGND sg13g2_decap_4
XFILLER_23_80 VPWR VGND sg13g2_decap_8
XFILLER_30_214 VPWR VGND sg13g2_decap_8
XFILLER_31_737 VPWR VGND sg13g2_fill_1
XFILLER_7_476 VPWR VGND sg13g2_decap_8
X_0630_ _0105_ _0382_ _0383_ net49 _0234_ VPWR VGND sg13g2_a22oi_1
X_0561_ VGND VPWR net25 daisychain\[23\] _0332_ net42 sg13g2_a21oi_1
X_0492_ _0200_ net59 _0279_ _0280_ VPWR VGND sg13g2_a21o_1
XFILLER_24_4 VPWR VGND sg13g2_fill_1
XFILLER_38_314 VPWR VGND sg13g2_decap_8
X_1044_ state\[60\] net11 VPWR VGND sg13g2_buf_1
XFILLER_0_84 VPWR VGND sg13g2_decap_8
XFILLER_21_225 VPWR VGND sg13g2_decap_8
XFILLER_34_586 VPWR VGND sg13g2_decap_8
XFILLER_9_60 VPWR VGND sg13g2_decap_8
X_0828_ VPWR _0045_ state\[21\] VGND sg13g2_inv_1
X_0759_ _0376_ VPWR _0167_ VGND net93 _0029_ sg13g2_o21ai_1
XFILLER_28_25 VPWR VGND sg13g2_decap_8
XFILLER_29_314 VPWR VGND sg13g2_decap_8
XFILLER_25_575 VPWR VGND sg13g2_decap_8
XFILLER_37_391 VPWR VGND sg13g2_decap_8
XFILLER_44_35 VPWR VGND sg13g2_decap_8
XFILLER_12_258 VPWR VGND sg13g2_decap_8
XFILLER_40_567 VPWR VGND sg13g2_decap_8
Xclkbuf_5_16__f_clk clknet_5_16__leaf_clk clknet_4_8_0_clk VPWR VGND sg13g2_buf_16
XFILLER_9_719 VPWR VGND sg13g2_fill_1
XFILLER_0_630 VPWR VGND sg13g2_fill_2
XFILLER_5_18 VPWR VGND sg13g2_decap_8
XFILLER_4_424 VPWR VGND sg13g2_decap_8
XFILLER_47_133 VPWR VGND sg13g2_decap_8
XFILLER_48_623 VPWR VGND sg13g2_decap_8
XFILLER_16_575 VPWR VGND sg13g2_decap_8
XFILLER_31_501 VPWR VGND sg13g2_decap_8
XFILLER_31_578 VPWR VGND sg13g2_decap_8
XFILLER_43_350 VPWR VGND sg13g2_decap_8
XFILLER_11_291 VPWR VGND sg13g2_decap_8
X_0613_ VGND VPWR net29 daisychain\[36\] _0371_ net45 sg13g2_a21oi_1
XFILLER_7_273 VPWR VGND sg13g2_decap_8
XFILLER_38_111 VPWR VGND sg13g2_decap_8
XFILLER_39_612 VPWR VGND sg13g2_fill_2
X_0544_ _0213_ net65 _0318_ _0319_ VPWR VGND sg13g2_a21o_1
X_0475_ net78 VPWR _0267_ VGND net57 state\[3\] sg13g2_o21ai_1
XFILLER_38_188 VPWR VGND sg13g2_decap_8
X_1027_ net100 VGND VPWR _0187_ state\[59\] clknet_5_25__leaf_clk sg13g2_dfrbpq_1
XFILLER_22_545 VPWR VGND sg13g2_decap_8
XFILLER_34_383 VPWR VGND sg13g2_decap_8
XFILLER_1_427 VPWR VGND sg13g2_decap_8
XFILLER_29_111 VPWR VGND sg13g2_decap_8
XFILLER_29_188 VPWR VGND sg13g2_decap_8
XFILLER_39_35 VPWR VGND sg13g2_decap_8
XFILLER_45_637 VPWR VGND sg13g2_decap_8
XFILLER_13_567 VPWR VGND sg13g2_decap_8
XFILLER_25_372 VPWR VGND sg13g2_decap_8
XFILLER_32_309 VPWR VGND sg13g2_decap_8
XFILLER_44_147 VPWR VGND sg13g2_decap_8
XFILLER_40_364 VPWR VGND sg13g2_decap_8
XFILLER_4_221 VPWR VGND sg13g2_decap_8
XFILLER_20_92 VPWR VGND sg13g2_decap_8
XFILLER_4_298 VPWR VGND sg13g2_decap_8
XFILLER_48_420 VPWR VGND sg13g2_decap_8
XFILLER_29_90 VPWR VGND sg13g2_decap_8
XFILLER_35_158 VPWR VGND sg13g2_decap_8
XFILLER_36_604 VPWR VGND sg13g2_decap_8
XFILLER_48_497 VPWR VGND sg13g2_decap_8
XFILLER_16_372 VPWR VGND sg13g2_decap_8
XFILLER_31_375 VPWR VGND sg13g2_decap_8
XFILLER_6_61 VPWR VGND sg13g2_decap_8
XFILLER_39_420 VPWR VGND sg13g2_decap_8
X_0527_ net85 VPWR _0306_ VGND net63 state\[16\] sg13g2_o21ai_1
X_0458_ VPWR _0023_ state\[62\] VGND sg13g2_inv_1
XFILLER_22_342 VPWR VGND sg13g2_decap_8
XFILLER_26_169 VPWR VGND sg13g2_decap_8
XFILLER_27_637 VPWR VGND sg13g2_decap_8
XFILLER_34_180 VPWR VGND sg13g2_decap_8
XFILLER_10_559 VPWR VGND sg13g2_decap_8
XFILLER_41_14 VPWR VGND sg13g2_decap_8
XFILLER_1_224 VPWR VGND sg13g2_decap_8
XFILLER_49_228 VPWR VGND sg13g2_decap_8
XFILLER_17_147 VPWR VGND sg13g2_decap_8
XFILLER_18_659 VPWR VGND sg13g2_decap_4
XFILLER_45_434 VPWR VGND sg13g2_decap_8
XFILLER_13_353 VPWR VGND sg13g2_decap_8
XFILLER_14_821 VPWR VGND sg13g2_fill_2
XFILLER_32_106 VPWR VGND sg13g2_decap_8
XFILLER_40_161 VPWR VGND sg13g2_decap_8
XFILLER_9_368 VPWR VGND sg13g2_decap_8
XFILLER_49_795 VPWR VGND sg13g2_decap_8
XFILLER_36_412 VPWR VGND sg13g2_decap_8
XFILLER_36_489 VPWR VGND sg13g2_decap_8
XFILLER_48_294 VPWR VGND sg13g2_decap_8
XFILLER_11_39 VPWR VGND sg13g2_decap_8
XFILLER_20_813 VPWR VGND sg13g2_decap_8
XFILLER_31_172 VPWR VGND sg13g2_decap_8
XFILLER_27_434 VPWR VGND sg13g2_decap_8
XFILLER_36_36 VPWR VGND sg13g2_decap_8
XFILLER_36_69 VPWR VGND sg13g2_decap_8
XFILLER_39_294 VPWR VGND sg13g2_decap_8
XFILLER_14_139 VPWR VGND sg13g2_decap_8
XFILLER_23_640 VPWR VGND sg13g2_decap_8
XFILLER_23_684 VPWR VGND sg13g2_decap_8
XFILLER_23_695 VPWR VGND sg13g2_fill_1
XFILLER_42_448 VPWR VGND sg13g2_decap_8
XFILLER_10_356 VPWR VGND sg13g2_decap_8
XFILLER_2_522 VPWR VGND sg13g2_decap_8
XFILLER_6_327 VPWR VGND sg13g2_decap_8
XFILLER_37_209 VPWR VGND sg13g2_decap_8
XFILLER_14_640 VPWR VGND sg13g2_fill_2
XFILLER_18_456 VPWR VGND sg13g2_decap_8
XFILLER_33_426 VPWR VGND sg13g2_decap_8
XFILLER_45_231 VPWR VGND sg13g2_decap_8
XFILLER_13_150 VPWR VGND sg13g2_decap_8
X_0861_ VPWR _0230_ daisychain\[37\] VGND sg13g2_inv_1
X_0930_ net100 VGND VPWR _0090_ daisychain\[26\] clknet_5_10__leaf_clk sg13g2_dfrbpq_1
X_0792_ VPWR _0057_ state\[3\] VGND sg13g2_inv_1
XFILLER_9_165 VPWR VGND sg13g2_decap_8
XFILLER_5_382 VPWR VGND sg13g2_decap_8
XFILLER_3_95 VPWR VGND sg13g2_decap_8
XFILLER_49_592 VPWR VGND sg13g2_decap_8
XFILLER_11_109 VPWR VGND sg13g2_decap_8
XFILLER_20_610 VPWR VGND sg13g2_decap_8
XFILLER_24_459 VPWR VGND sg13g2_decap_8
XFILLER_32_470 VPWR VGND sg13g2_decap_8
XFILLER_36_286 VPWR VGND sg13g2_decap_8
XFILLER_20_687 VPWR VGND sg13g2_decap_8
XFILLER_20_698 VPWR VGND sg13g2_fill_2
XFILLER_3_319 VPWR VGND sg13g2_decap_8
XFILLER_47_35 VPWR VGND sg13g2_decap_8
XFILLER_47_518 VPWR VGND sg13g2_decap_8
Xfanout100 net119 net100 VPWR VGND sg13g2_buf_1
Xfanout111 net112 net111 VPWR VGND sg13g2_buf_1
XFILLER_15_426 VPWR VGND sg13g2_decap_8
XFILLER_27_231 VPWR VGND sg13g2_decap_8
XFILLER_42_245 VPWR VGND sg13g2_decap_8
XFILLER_10_153 VPWR VGND sg13g2_decap_8
XFILLER_6_124 VPWR VGND sg13g2_decap_8
XFILLER_2_396 VPWR VGND sg13g2_decap_8
XFILLER_38_507 VPWR VGND sg13g2_fill_2
XFILLER_38_529 VPWR VGND sg13g2_decap_8
XFILLER_18_253 VPWR VGND sg13g2_decap_8
XFILLER_21_407 VPWR VGND sg13g2_decap_8
XFILLER_33_223 VPWR VGND sg13g2_decap_8
XFILLER_34_735 VPWR VGND sg13g2_fill_2
XFILLER_37_90 VPWR VGND sg13g2_decap_8
XFILLER_46_595 VPWR VGND sg13g2_decap_8
X_0913_ net102 VGND VPWR _0073_ daisychain\[9\] clknet_5_15__leaf_clk sg13g2_dfrbpq_1
X_0844_ VPWR _0053_ state\[29\] VGND sg13g2_inv_1
X_0775_ _0424_ VPWR _0183_ VGND net90 _0015_ sg13g2_o21ai_1
XFILLER_45_0 VPWR VGND sg13g2_decap_8
XFILLER_20_484 VPWR VGND sg13g2_decap_8
XFILLER_24_267 VPWR VGND sg13g2_decap_8
XFILLER_33_48 VPWR VGND sg13g2_decap_8
XFILLER_0_801 VPWR VGND sg13g2_decap_8
XFILLER_3_116 VPWR VGND sg13g2_decap_8
XFILLER_47_315 VPWR VGND sg13g2_decap_8
XFILLER_48_805 VPWR VGND sg13g2_decap_8
XFILLER_15_223 VPWR VGND sg13g2_decap_8
XFILLER_16_746 VPWR VGND sg13g2_fill_2
XFILLER_31_749 VPWR VGND sg13g2_fill_2
XFILLER_43_532 VPWR VGND sg13g2_decap_8
XFILLER_11_440 VPWR VGND sg13g2_decap_8
XFILLER_7_455 VPWR VGND sg13g2_decap_8
XFILLER_2_193 VPWR VGND sg13g2_decap_8
X_0560_ _0217_ net58 _0330_ _0331_ VPWR VGND sg13g2_a21o_1
X_0491_ net79 VPWR _0279_ VGND net59 state\[7\] sg13g2_o21ai_1
XFILLER_0_63 VPWR VGND sg13g2_decap_8
XFILLER_17_4 VPWR VGND sg13g2_fill_1
XFILLER_19_595 VPWR VGND sg13g2_decap_8
XFILLER_46_392 VPWR VGND sg13g2_decap_8
X_1043_ state\[59\] net10 VPWR VGND sg13g2_buf_1
XFILLER_21_204 VPWR VGND sg13g2_decap_8
XFILLER_34_565 VPWR VGND sg13g2_decap_8
X_0827_ VPWR _0213_ daisychain\[20\] VGND sg13g2_inv_1
X_0758_ _0373_ VPWR _0166_ VGND net93 _0028_ sg13g2_o21ai_1
XFILLER_0_119 VPWR VGND sg13g2_decap_8
X_0689_ VGND VPWR net29 daisychain\[55\] _0428_ net45 sg13g2_a21oi_1
XFILLER_25_554 VPWR VGND sg13g2_decap_8
XFILLER_37_370 VPWR VGND sg13g2_decap_8
XFILLER_44_14 VPWR VGND sg13g2_decap_8
XFILLER_44_329 VPWR VGND sg13g2_decap_8
XFILLER_12_237 VPWR VGND sg13g2_decap_8
XFILLER_20_281 VPWR VGND sg13g2_decap_8
XFILLER_40_546 VPWR VGND sg13g2_decap_8
XFILLER_4_403 VPWR VGND sg13g2_decap_8
XFILLER_48_602 VPWR VGND sg13g2_decap_8
XFILLER_0_686 VPWR VGND sg13g2_fill_2
XFILLER_18_92 VPWR VGND sg13g2_decap_8
XFILLER_47_112 VPWR VGND sg13g2_decap_8
XFILLER_47_189 VPWR VGND sg13g2_decap_8
XFILLER_48_679 VPWR VGND sg13g2_decap_8
XFILLER_16_554 VPWR VGND sg13g2_decap_8
XFILLER_31_557 VPWR VGND sg13g2_decap_8
XFILLER_11_270 VPWR VGND sg13g2_decap_8
X_0612_ _0230_ net68 _0369_ _0370_ VPWR VGND sg13g2_a21o_1
XFILLER_7_252 VPWR VGND sg13g2_decap_8
XFILLER_3_480 VPWR VGND sg13g2_decap_8
X_0543_ net85 VPWR _0318_ VGND net65 state\[20\] sg13g2_o21ai_1
X_0474_ _0066_ _0265_ _0266_ net35 _0195_ VPWR VGND sg13g2_a22oi_1
XFILLER_19_392 VPWR VGND sg13g2_decap_8
XFILLER_22_524 VPWR VGND sg13g2_decap_8
XFILLER_34_362 VPWR VGND sg13g2_decap_8
XFILLER_38_167 VPWR VGND sg13g2_decap_8
X_1026_ net100 VGND VPWR _0186_ state\[58\] clknet_5_24__leaf_clk sg13g2_dfrbpq_1
Xclkbuf_5_22__f_clk clknet_5_22__leaf_clk clknet_4_11_0_clk VPWR VGND sg13g2_buf_16
XFILLER_1_406 VPWR VGND sg13g2_decap_8
XFILLER_39_14 VPWR VGND sg13g2_decap_8
XFILLER_17_329 VPWR VGND sg13g2_decap_8
XFILLER_18_808 VPWR VGND sg13g2_decap_8
XFILLER_29_167 VPWR VGND sg13g2_decap_8
XFILLER_44_126 VPWR VGND sg13g2_decap_8
XFILLER_45_616 VPWR VGND sg13g2_decap_8
XFILLER_13_546 VPWR VGND sg13g2_decap_8
XFILLER_25_351 VPWR VGND sg13g2_decap_8
XFILLER_40_343 VPWR VGND sg13g2_decap_8
XFILLER_4_200 VPWR VGND sg13g2_decap_8
XFILLER_0_483 VPWR VGND sg13g2_decap_8
XFILLER_20_71 VPWR VGND sg13g2_decap_8
XFILLER_4_277 VPWR VGND sg13g2_decap_8
XFILLER_16_351 VPWR VGND sg13g2_decap_8
XFILLER_32_811 VPWR VGND sg13g2_fill_2
XFILLER_35_137 VPWR VGND sg13g2_decap_8
XFILLER_48_476 VPWR VGND sg13g2_decap_8
XFILLER_31_354 VPWR VGND sg13g2_decap_8
X_0526_ _0079_ _0304_ _0305_ net43 _0208_ VPWR VGND sg13g2_a22oi_1
XFILLER_8_594 VPWR VGND sg13g2_fill_2
XFILLER_6_40 VPWR VGND sg13g2_decap_8
XFILLER_27_616 VPWR VGND sg13g2_decap_8
XFILLER_39_476 VPWR VGND sg13g2_decap_8
X_0457_ VPWR _0254_ daisychain\[61\] VGND sg13g2_inv_1
XFILLER_22_321 VPWR VGND sg13g2_decap_8
XFILLER_23_822 VPWR VGND sg13g2_fill_1
XFILLER_26_148 VPWR VGND sg13g2_decap_8
X_1009_ net114 VGND VPWR _0169_ state\[41\] clknet_5_19__leaf_clk sg13g2_dfrbpq_1
XFILLER_10_538 VPWR VGND sg13g2_decap_8
XFILLER_22_398 VPWR VGND sg13g2_decap_8
XFILLER_6_509 VPWR VGND sg13g2_decap_8
XFILLER_1_203 VPWR VGND sg13g2_decap_8
XFILLER_49_207 VPWR VGND sg13g2_decap_8
XFILLER_17_126 VPWR VGND sg13g2_decap_8
XFILLER_18_638 VPWR VGND sg13g2_decap_8
XFILLER_33_608 VPWR VGND sg13g2_decap_8
XFILLER_45_413 VPWR VGND sg13g2_decap_8
XFILLER_13_332 VPWR VGND sg13g2_decap_8
XFILLER_40_140 VPWR VGND sg13g2_decap_8
XFILLER_41_630 VPWR VGND sg13g2_decap_8
XFILLER_9_347 VPWR VGND sg13g2_decap_8
XFILLER_31_81 VPWR VGND sg13g2_decap_8
XFILLER_5_597 VPWR VGND sg13g2_fill_2
XFILLER_0_280 VPWR VGND sg13g2_decap_8
XFILLER_49_774 VPWR VGND sg13g2_decap_8
XFILLER_48_273 VPWR VGND sg13g2_decap_8
XFILLER_23_129 VPWR VGND sg13g2_decap_8
XFILLER_31_151 VPWR VGND sg13g2_decap_8
XFILLER_36_468 VPWR VGND sg13g2_decap_8
XFILLER_44_490 VPWR VGND sg13g2_decap_8
XFILLER_11_18 VPWR VGND sg13g2_decap_8
XFILLER_8_391 VPWR VGND sg13g2_decap_8
X_0509_ VGND VPWR net23 daisychain\[10\] _0293_ net36 sg13g2_a21oi_1
XFILLER_14_118 VPWR VGND sg13g2_decap_8
XFILLER_15_608 VPWR VGND sg13g2_decap_8
XFILLER_27_413 VPWR VGND sg13g2_decap_8
XFILLER_39_273 VPWR VGND sg13g2_decap_8
XFILLER_42_427 VPWR VGND sg13g2_decap_8
XFILLER_10_335 VPWR VGND sg13g2_decap_8
XFILLER_22_195 VPWR VGND sg13g2_decap_8
XFILLER_6_306 VPWR VGND sg13g2_decap_8
XFILLER_2_501 VPWR VGND sg13g2_decap_8
XFILLER_18_435 VPWR VGND sg13g2_decap_8
XFILLER_2_589 VPWR VGND sg13g2_fill_1
XFILLER_45_210 VPWR VGND sg13g2_decap_8
XFILLER_46_700 VPWR VGND sg13g2_decap_8
XFILLER_26_92 VPWR VGND sg13g2_decap_8
XFILLER_33_405 VPWR VGND sg13g2_decap_8
XFILLER_45_287 VPWR VGND sg13g2_decap_8
XFILLER_46_766 VPWR VGND sg13g2_fill_1
XFILLER_46_777 VPWR VGND sg13g2_fill_2
XFILLER_42_91 VPWR VGND sg13g2_decap_8
X_0860_ VPWR _0027_ state\[37\] VGND sg13g2_inv_1
X_0791_ VPWR _0195_ daisychain\[2\] VGND sg13g2_inv_1
XFILLER_9_144 VPWR VGND sg13g2_decap_8
XFILLER_3_74 VPWR VGND sg13g2_decap_8
XFILLER_5_361 VPWR VGND sg13g2_decap_8
XFILLER_36_265 VPWR VGND sg13g2_decap_8
XFILLER_49_571 VPWR VGND sg13g2_decap_8
XFILLER_17_490 VPWR VGND sg13g2_decap_8
XFILLER_20_666 VPWR VGND sg13g2_decap_8
XFILLER_24_438 VPWR VGND sg13g2_decap_8
X_0989_ net106 VGND VPWR _0149_ state\[21\] clknet_5_7__leaf_clk sg13g2_dfrbpq_1
XFILLER_27_210 VPWR VGND sg13g2_decap_8
XFILLER_28_711 VPWR VGND sg13g2_decap_8
XFILLER_47_14 VPWR VGND sg13g2_decap_8
Xfanout101 net103 net101 VPWR VGND sg13g2_buf_1
Xfanout112 net118 net112 VPWR VGND sg13g2_buf_1
XFILLER_15_405 VPWR VGND sg13g2_decap_8
XFILLER_27_287 VPWR VGND sg13g2_decap_8
XFILLER_42_224 VPWR VGND sg13g2_decap_8
XFILLER_10_132 VPWR VGND sg13g2_decap_8
XFILLER_11_633 VPWR VGND sg13g2_decap_4
XFILLER_23_493 VPWR VGND sg13g2_decap_8
XFILLER_7_626 VPWR VGND sg13g2_decap_8
XFILLER_6_103 VPWR VGND sg13g2_decap_8
XFILLER_12_83 VPWR VGND sg13g2_decap_8
XFILLER_2_375 VPWR VGND sg13g2_decap_8
XFILLER_18_232 VPWR VGND sg13g2_decap_8
XFILLER_19_8 VPWR VGND sg13g2_fill_1
XFILLER_33_202 VPWR VGND sg13g2_decap_8
XFILLER_46_574 VPWR VGND sg13g2_decap_8
Xclkbuf_5_3__f_clk clknet_5_3__leaf_clk clknet_4_1_0_clk VPWR VGND sg13g2_buf_16
XFILLER_14_482 VPWR VGND sg13g2_decap_8
XFILLER_33_279 VPWR VGND sg13g2_decap_8
X_0912_ net102 VGND VPWR _0072_ daisychain\[8\] clknet_5_15__leaf_clk sg13g2_dfrbpq_1
X_0843_ VPWR _0221_ daisychain\[28\] VGND sg13g2_inv_1
X_0774_ _0421_ VPWR _0182_ VGND net90 _0014_ sg13g2_o21ai_1
XFILLER_38_0 VPWR VGND sg13g2_decap_8
XFILLER_17_17 VPWR VGND sg13g2_fill_2
XFILLER_17_28 VPWR VGND sg13g2_fill_1
XFILLER_24_246 VPWR VGND sg13g2_decap_8
XFILLER_20_463 VPWR VGND sg13g2_decap_8
XFILLER_15_202 VPWR VGND sg13g2_decap_8
XFILLER_28_585 VPWR VGND sg13g2_decap_8
XFILLER_43_511 VPWR VGND sg13g2_decap_8
XFILLER_15_279 VPWR VGND sg13g2_decap_8
XFILLER_23_290 VPWR VGND sg13g2_decap_8
XFILLER_30_249 VPWR VGND sg13g2_decap_8
XFILLER_43_588 VPWR VGND sg13g2_decap_8
XFILLER_3_640 VPWR VGND sg13g2_decap_4
XFILLER_7_434 VPWR VGND sg13g2_decap_8
XFILLER_2_172 VPWR VGND sg13g2_decap_8
X_0490_ _0070_ _0277_ _0278_ net36 _0199_ VPWR VGND sg13g2_a22oi_1
XFILLER_0_42 VPWR VGND sg13g2_decap_8
XFILLER_19_574 VPWR VGND sg13g2_decap_8
XFILLER_34_544 VPWR VGND sg13g2_decap_8
XFILLER_38_349 VPWR VGND sg13g2_decap_8
XFILLER_46_371 VPWR VGND sg13g2_decap_8
X_1042_ state\[58\] net9 VPWR VGND sg13g2_buf_1
XFILLER_15_791 VPWR VGND sg13g2_fill_2
XFILLER_30_783 VPWR VGND sg13g2_fill_2
XFILLER_9_95 VPWR VGND sg13g2_decap_8
X_0826_ VPWR _0044_ state\[20\] VGND sg13g2_inv_1
X_0757_ _0370_ VPWR _0165_ VGND net90 _0027_ sg13g2_o21ai_1
X_0688_ _0249_ net74 _0426_ _0427_ VPWR VGND sg13g2_a21o_1
XFILLER_29_349 VPWR VGND sg13g2_decap_8
XFILLER_44_308 VPWR VGND sg13g2_decap_8
Xclkbuf_4_15_0_clk clknet_0_clk clknet_4_15_0_clk VPWR VGND sg13g2_buf_8
XFILLER_12_216 VPWR VGND sg13g2_decap_8
XFILLER_25_533 VPWR VGND sg13g2_decap_8
XFILLER_40_525 VPWR VGND sg13g2_decap_8
XFILLER_8_209 VPWR VGND sg13g2_decap_8
XFILLER_20_260 VPWR VGND sg13g2_decap_8
XFILLER_0_665 VPWR VGND sg13g2_decap_8
XFILLER_4_459 VPWR VGND sg13g2_decap_8
XFILLER_16_533 VPWR VGND sg13g2_decap_8
XFILLER_18_71 VPWR VGND sg13g2_decap_8
XFILLER_28_382 VPWR VGND sg13g2_decap_8
XFILLER_35_319 VPWR VGND sg13g2_decap_8
XFILLER_47_168 VPWR VGND sg13g2_decap_8
XFILLER_48_658 VPWR VGND sg13g2_decap_8
XFILLER_31_536 VPWR VGND sg13g2_decap_8
XFILLER_43_385 VPWR VGND sg13g2_decap_8
XFILLER_7_231 VPWR VGND sg13g2_decap_8
X_0611_ net89 VPWR _0369_ VGND net68 state\[37\] sg13g2_o21ai_1
X_0542_ _0083_ _0316_ _0317_ net41 _0212_ VPWR VGND sg13g2_a22oi_1
XFILLER_27_809 VPWR VGND sg13g2_decap_8
XFILLER_38_146 VPWR VGND sg13g2_decap_8
XFILLER_39_614 VPWR VGND sg13g2_fill_1
X_0473_ VGND VPWR net31 daisychain\[1\] _0266_ net35 sg13g2_a21oi_1
XFILLER_19_371 VPWR VGND sg13g2_decap_8
XFILLER_22_503 VPWR VGND sg13g2_decap_8
XFILLER_34_341 VPWR VGND sg13g2_decap_8
X_1025_ net100 VGND VPWR _0185_ state\[57\] clknet_5_25__leaf_clk sg13g2_dfrbpq_1
XFILLER_30_39 VPWR VGND sg13g2_decap_8
X_0809_ VPWR _0204_ daisychain\[11\] VGND sg13g2_inv_1
XFILLER_17_308 VPWR VGND sg13g2_decap_8
XFILLER_25_330 VPWR VGND sg13g2_decap_8
XFILLER_29_146 VPWR VGND sg13g2_decap_8
XFILLER_44_105 VPWR VGND sg13g2_decap_8
XFILLER_13_525 VPWR VGND sg13g2_decap_8
XFILLER_40_322 VPWR VGND sg13g2_decap_8
XFILLER_40_399 VPWR VGND sg13g2_decap_8
XFILLER_4_256 VPWR VGND sg13g2_decap_8
XFILLER_0_462 VPWR VGND sg13g2_decap_8
XFILLER_48_455 VPWR VGND sg13g2_decap_8
XFILLER_16_330 VPWR VGND sg13g2_decap_8
XFILLER_31_333 VPWR VGND sg13g2_decap_8
XFILLER_35_116 VPWR VGND sg13g2_decap_8
XFILLER_43_182 VPWR VGND sg13g2_decap_8
XFILLER_44_672 VPWR VGND sg13g2_decap_8
XFILLER_45_91 VPWR VGND sg13g2_decap_8
XANTENNA_1 VPWR VGND digitalen.g\[1\].u.OUTP sg13g2_antennanp
XFILLER_8_562 VPWR VGND sg13g2_decap_8
X_0525_ VGND VPWR net26 daisychain\[14\] _0305_ net43 sg13g2_a21oi_1
X_0456_ VPWR _0021_ state\[61\] VGND sg13g2_inv_1
XFILLER_6_96 VPWR VGND sg13g2_decap_8
XFILLER_26_127 VPWR VGND sg13g2_decap_8
XFILLER_39_455 VPWR VGND sg13g2_decap_8
XFILLER_42_609 VPWR VGND sg13g2_decap_8
XFILLER_22_300 VPWR VGND sg13g2_decap_8
XFILLER_22_377 VPWR VGND sg13g2_decap_8
XFILLER_23_801 VPWR VGND sg13g2_decap_8
XFILLER_35_683 VPWR VGND sg13g2_decap_8
XFILLER_41_119 VPWR VGND sg13g2_decap_8
X_1008_ net114 VGND VPWR _0168_ state\[40\] clknet_5_18__leaf_clk sg13g2_dfrbpq_1
XFILLER_41_49 VPWR VGND sg13g2_decap_8
XFILLER_18_617 VPWR VGND sg13g2_decap_8
XFILLER_1_259 VPWR VGND sg13g2_decap_8
XFILLER_13_311 VPWR VGND sg13g2_decap_8
XFILLER_17_105 VPWR VGND sg13g2_decap_8
XFILLER_26_672 VPWR VGND sg13g2_decap_8
XFILLER_45_469 VPWR VGND sg13g2_decap_8
XFILLER_15_83 VPWR VGND sg13g2_decap_8
XFILLER_31_60 VPWR VGND sg13g2_decap_8
XFILLER_40_196 VPWR VGND sg13g2_decap_8
XFILLER_9_326 VPWR VGND sg13g2_decap_8
XFILLER_5_587 VPWR VGND sg13g2_decap_4
XFILLER_36_447 VPWR VGND sg13g2_decap_8
XFILLER_49_753 VPWR VGND sg13g2_decap_8
XFILLER_48_252 VPWR VGND sg13g2_decap_8
XFILLER_23_108 VPWR VGND sg13g2_decap_8
XFILLER_31_130 VPWR VGND sg13g2_decap_8
XFILLER_8_370 VPWR VGND sg13g2_decap_8
XFILLER_39_252 VPWR VGND sg13g2_decap_8
X_0508_ _0204_ net58 _0291_ _0292_ VPWR VGND sg13g2_a21o_1
XFILLER_27_469 VPWR VGND sg13g2_decap_8
XFILLER_35_480 VPWR VGND sg13g2_decap_8
XFILLER_42_406 VPWR VGND sg13g2_decap_8
XFILLER_10_314 VPWR VGND sg13g2_decap_8
XFILLER_22_174 VPWR VGND sg13g2_decap_8
XFILLER_2_557 VPWR VGND sg13g2_decap_8
XFILLER_18_414 VPWR VGND sg13g2_decap_8
XFILLER_46_723 VPWR VGND sg13g2_decap_8
XFILLER_46_734 VPWR VGND sg13g2_fill_1
XFILLER_13_185 VPWR VGND sg13g2_decap_8
XFILLER_26_491 VPWR VGND sg13g2_decap_8
XFILLER_26_71 VPWR VGND sg13g2_decap_8
XFILLER_41_483 VPWR VGND sg13g2_decap_8
XFILLER_45_266 VPWR VGND sg13g2_decap_8
XFILLER_9_123 VPWR VGND sg13g2_decap_8
XFILLER_42_70 VPWR VGND sg13g2_decap_8
X_0790_ VPWR _0054_ state\[2\] VGND sg13g2_inv_1
XFILLER_5_340 VPWR VGND sg13g2_decap_8
XFILLER_3_53 VPWR VGND sg13g2_decap_8
XFILLER_49_550 VPWR VGND sg13g2_decap_8
XFILLER_36_244 VPWR VGND sg13g2_decap_8
XFILLER_20_645 VPWR VGND sg13g2_decap_8
X_0988_ net108 VGND VPWR _0148_ state\[20\] clknet_5_7__leaf_clk sg13g2_dfrbpq_1
Xfanout102 net103 net102 VPWR VGND sg13g2_buf_1
Xfanout113 net114 net113 VPWR VGND sg13g2_buf_1
XFILLER_23_472 VPWR VGND sg13g2_decap_8
XFILLER_27_266 VPWR VGND sg13g2_decap_8
XFILLER_28_789 VPWR VGND sg13g2_fill_1
XFILLER_42_203 VPWR VGND sg13g2_decap_8
XFILLER_10_111 VPWR VGND sg13g2_decap_8
XFILLER_10_188 VPWR VGND sg13g2_decap_8
XFILLER_12_62 VPWR VGND sg13g2_decap_8
XFILLER_6_159 VPWR VGND sg13g2_decap_8
XFILLER_2_354 VPWR VGND sg13g2_decap_8
XFILLER_38_509 VPWR VGND sg13g2_fill_1
XFILLER_18_211 VPWR VGND sg13g2_decap_8
XFILLER_18_288 VPWR VGND sg13g2_decap_8
XFILLER_34_737 VPWR VGND sg13g2_fill_1
XFILLER_46_553 VPWR VGND sg13g2_decap_8
XFILLER_14_461 VPWR VGND sg13g2_decap_8
XFILLER_33_258 VPWR VGND sg13g2_decap_8
XFILLER_41_280 VPWR VGND sg13g2_decap_8
X_0911_ net101 VGND VPWR _0071_ daisychain\[7\] clknet_5_13__leaf_clk sg13g2_dfrbpq_1
X_0842_ VPWR _0052_ state\[28\] VGND sg13g2_inv_1
X_0773_ _0418_ VPWR _0181_ VGND net94 _0013_ sg13g2_o21ai_1
XFILLER_24_225 VPWR VGND sg13g2_decap_8
XFILLER_25_726 VPWR VGND sg13g2_fill_2
XFILLER_37_597 VPWR VGND sg13g2_decap_8
XFILLER_20_442 VPWR VGND sg13g2_decap_8
XFILLER_16_715 VPWR VGND sg13g2_decap_4
XFILLER_28_564 VPWR VGND sg13g2_decap_8
XFILLER_15_258 VPWR VGND sg13g2_decap_8
XFILLER_24_781 VPWR VGND sg13g2_fill_2
XFILLER_30_228 VPWR VGND sg13g2_decap_8
XFILLER_43_567 VPWR VGND sg13g2_decap_8
XFILLER_7_413 VPWR VGND sg13g2_decap_8
XFILLER_11_486 VPWR VGND sg13g2_decap_8
XFILLER_23_94 VPWR VGND sg13g2_decap_8
XFILLER_2_151 VPWR VGND sg13g2_decap_8
XFILLER_38_328 VPWR VGND sg13g2_decap_8
XFILLER_48_91 VPWR VGND sg13g2_decap_8
XFILLER_0_21 VPWR VGND sg13g2_decap_8
XFILLER_0_98 VPWR VGND sg13g2_decap_8
XFILLER_19_553 VPWR VGND sg13g2_decap_8
XFILLER_34_523 VPWR VGND sg13g2_decap_8
XFILLER_46_350 VPWR VGND sg13g2_decap_8
X_1041_ state\[57\] net8 VPWR VGND sg13g2_buf_1
XFILLER_21_239 VPWR VGND sg13g2_decap_8
X_0825_ VPWR _0212_ daisychain\[19\] VGND sg13g2_inv_1
XFILLER_9_74 VPWR VGND sg13g2_decap_8
X_0756_ _0367_ VPWR _0164_ VGND net88 _0026_ sg13g2_o21ai_1
X_0687_ net89 VPWR _0426_ VGND net74 state\[56\] sg13g2_o21ai_1
XFILLER_25_512 VPWR VGND sg13g2_decap_8
XFILLER_28_39 VPWR VGND sg13g2_decap_8
XFILLER_29_328 VPWR VGND sg13g2_decap_8
XFILLER_21_740 VPWR VGND sg13g2_fill_1
XFILLER_25_589 VPWR VGND sg13g2_decap_8
XFILLER_40_504 VPWR VGND sg13g2_decap_8
XFILLER_44_49 VPWR VGND sg13g2_decap_8
XFILLER_4_438 VPWR VGND sg13g2_decap_8
XFILLER_0_611 VPWR VGND sg13g2_decap_4
XFILLER_0_699 VPWR VGND sg13g2_decap_8
XFILLER_48_637 VPWR VGND sg13g2_decap_8
XFILLER_16_512 VPWR VGND sg13g2_decap_8
XFILLER_16_589 VPWR VGND sg13g2_decap_8
XFILLER_18_50 VPWR VGND sg13g2_decap_8
XFILLER_28_361 VPWR VGND sg13g2_decap_8
XFILLER_31_515 VPWR VGND sg13g2_decap_8
XFILLER_43_364 VPWR VGND sg13g2_decap_8
XFILLER_47_147 VPWR VGND sg13g2_decap_8
XFILLER_34_82 VPWR VGND sg13g2_decap_8
XFILLER_7_210 VPWR VGND sg13g2_decap_8
X_0610_ _0100_ _0367_ _0368_ net45 _0229_ VPWR VGND sg13g2_a22oi_1
X_0541_ VGND VPWR net25 daisychain\[18\] _0317_ net40 sg13g2_a21oi_1
X_0472_ _0195_ net57 _0264_ _0265_ VPWR VGND sg13g2_a21o_1
XFILLER_7_287 VPWR VGND sg13g2_decap_8
XFILLER_19_350 VPWR VGND sg13g2_decap_8
XFILLER_22_4 VPWR VGND sg13g2_decap_8
XFILLER_26_309 VPWR VGND sg13g2_decap_8
XFILLER_38_125 VPWR VGND sg13g2_decap_8
X_1024_ net110 VGND VPWR _0184_ state\[56\] clknet_5_26__leaf_clk sg13g2_dfrbpq_1
XFILLER_22_559 VPWR VGND sg13g2_decap_8
XFILLER_34_320 VPWR VGND sg13g2_decap_8
XFILLER_34_397 VPWR VGND sg13g2_decap_8
XFILLER_30_18 VPWR VGND sg13g2_decap_8
XFILLER_30_592 VPWR VGND sg13g2_decap_8
X_0808_ VPWR _0034_ state\[11\] VGND sg13g2_inv_1
XFILLER_29_125 VPWR VGND sg13g2_decap_8
XFILLER_39_49 VPWR VGND sg13g2_decap_8
X_0739_ _0316_ VPWR _0147_ VGND net87 _0042_ sg13g2_o21ai_1
XFILLER_13_504 VPWR VGND sg13g2_decap_8
XFILLER_40_301 VPWR VGND sg13g2_decap_8
XFILLER_25_386 VPWR VGND sg13g2_decap_8
XFILLER_40_378 VPWR VGND sg13g2_decap_8
XFILLER_9_508 VPWR VGND sg13g2_decap_4
XFILLER_4_235 VPWR VGND sg13g2_decap_8
XFILLER_0_441 VPWR VGND sg13g2_decap_8
XFILLER_48_434 VPWR VGND sg13g2_decap_8
XFILLER_16_386 VPWR VGND sg13g2_decap_8
XFILLER_31_312 VPWR VGND sg13g2_decap_8
XFILLER_43_161 VPWR VGND sg13g2_decap_8
XFILLER_44_651 VPWR VGND sg13g2_decap_8
XFILLER_45_70 VPWR VGND sg13g2_decap_8
XANTENNA_2 VPWR VGND _0024_ sg13g2_antennanp
XFILLER_31_389 VPWR VGND sg13g2_decap_8
Xclkbuf_4_14_0_clk clknet_0_clk clknet_4_14_0_clk VPWR VGND sg13g2_buf_8
XFILLER_8_596 VPWR VGND sg13g2_fill_1
XFILLER_8_585 VPWR VGND sg13g2_fill_1
XFILLER_8_552 VPWR VGND sg13g2_decap_4
XFILLER_6_75 VPWR VGND sg13g2_decap_8
XFILLER_39_434 VPWR VGND sg13g2_decap_8
X_0524_ _0208_ net62 _0303_ _0304_ VPWR VGND sg13g2_a21o_1
X_0455_ VPWR _0253_ daisychain\[60\] VGND sg13g2_inv_1
XFILLER_13_0 VPWR VGND sg13g2_fill_2
XFILLER_25_29 VPWR VGND sg13g2_decap_8
XFILLER_26_106 VPWR VGND sg13g2_decap_8
X_1007_ net115 VGND VPWR _0167_ state\[39\] clknet_5_19__leaf_clk sg13g2_dfrbpq_1
XFILLER_22_356 VPWR VGND sg13g2_decap_8
XFILLER_34_194 VPWR VGND sg13g2_decap_8
XFILLER_41_28 VPWR VGND sg13g2_decap_8
XFILLER_1_238 VPWR VGND sg13g2_decap_8
XFILLER_13_367 VPWR VGND sg13g2_decap_8
XFILLER_15_62 VPWR VGND sg13g2_decap_8
XFILLER_25_183 VPWR VGND sg13g2_decap_8
XFILLER_41_676 VPWR VGND sg13g2_fill_1
XFILLER_45_448 VPWR VGND sg13g2_decap_8
XFILLER_9_305 VPWR VGND sg13g2_decap_8
XFILLER_40_175 VPWR VGND sg13g2_decap_8
XFILLER_5_522 VPWR VGND sg13g2_decap_8
XFILLER_5_599 VPWR VGND sg13g2_fill_1
XFILLER_49_732 VPWR VGND sg13g2_decap_8
XFILLER_17_651 VPWR VGND sg13g2_decap_8
XFILLER_36_426 VPWR VGND sg13g2_decap_8
XFILLER_48_231 VPWR VGND sg13g2_decap_8
XFILLER_16_183 VPWR VGND sg13g2_decap_8
XFILLER_17_695 VPWR VGND sg13g2_fill_1
XFILLER_31_186 VPWR VGND sg13g2_decap_8
XFILLER_32_610 VPWR VGND sg13g2_decap_8
XFILLER_32_665 VPWR VGND sg13g2_fill_2
XFILLER_39_231 VPWR VGND sg13g2_decap_8
X_0507_ net80 VPWR _0291_ VGND net58 state\[11\] sg13g2_o21ai_1
XFILLER_23_654 VPWR VGND sg13g2_decap_8
XFILLER_27_448 VPWR VGND sg13g2_decap_8
XFILLER_22_153 VPWR VGND sg13g2_decap_8
XFILLER_2_536 VPWR VGND sg13g2_decap_8
XFILLER_26_50 VPWR VGND sg13g2_decap_8
XFILLER_45_245 VPWR VGND sg13g2_decap_8
XFILLER_13_164 VPWR VGND sg13g2_decap_8
XFILLER_14_654 VPWR VGND sg13g2_fill_1
XFILLER_26_470 VPWR VGND sg13g2_decap_8
XFILLER_41_462 VPWR VGND sg13g2_decap_8
XFILLER_9_102 VPWR VGND sg13g2_decap_8
XFILLER_9_179 VPWR VGND sg13g2_decap_8
XFILLER_5_396 VPWR VGND sg13g2_decap_8
XFILLER_3_32 VPWR VGND sg13g2_decap_8
XFILLER_24_407 VPWR VGND sg13g2_decap_4
XFILLER_36_223 VPWR VGND sg13g2_decap_8
XFILLER_20_624 VPWR VGND sg13g2_decap_8
XFILLER_32_484 VPWR VGND sg13g2_decap_8
X_0987_ net108 VGND VPWR _0147_ state\[19\] clknet_5_21__leaf_clk sg13g2_dfrbpq_1
XFILLER_9_680 VPWR VGND sg13g2_decap_8
Xclkbuf_5_28__f_clk clknet_5_28__leaf_clk clknet_4_14_0_clk VPWR VGND sg13g2_buf_16
Xfanout103 net104 net103 VPWR VGND sg13g2_buf_1
Xfanout114 net117 net114 VPWR VGND sg13g2_buf_1
XFILLER_27_245 VPWR VGND sg13g2_decap_8
XFILLER_43_716 VPWR VGND sg13g2_fill_1
XFILLER_43_727 VPWR VGND sg13g2_decap_8
XFILLER_47_49 VPWR VGND sg13g2_decap_8
XFILLER_23_451 VPWR VGND sg13g2_decap_8
XFILLER_42_259 VPWR VGND sg13g2_decap_8
XFILLER_10_167 VPWR VGND sg13g2_decap_8
XFILLER_12_41 VPWR VGND sg13g2_decap_8
XFILLER_3_812 VPWR VGND sg13g2_decap_8
XFILLER_6_138 VPWR VGND sg13g2_decap_8
XFILLER_19_724 VPWR VGND sg13g2_fill_1
XFILLER_2_333 VPWR VGND sg13g2_decap_8
XFILLER_14_440 VPWR VGND sg13g2_decap_8
XFILLER_18_267 VPWR VGND sg13g2_decap_8
XFILLER_33_237 VPWR VGND sg13g2_decap_8
XFILLER_46_532 VPWR VGND sg13g2_decap_8
XFILLER_42_771 VPWR VGND sg13g2_fill_2
X_0910_ net101 VGND VPWR _0070_ daisychain\[6\] clknet_5_2__leaf_clk sg13g2_dfrbpq_1
X_0841_ VPWR _0220_ daisychain\[27\] VGND sg13g2_inv_1
X_0772_ _0415_ VPWR _0180_ VGND net94 _0012_ sg13g2_o21ai_1
XFILLER_5_193 VPWR VGND sg13g2_decap_8
XFILLER_37_543 VPWR VGND sg13g2_decap_8
XFILLER_37_576 VPWR VGND sg13g2_decap_8
XFILLER_20_421 VPWR VGND sg13g2_decap_8
XFILLER_24_204 VPWR VGND sg13g2_decap_8
XFILLER_32_281 VPWR VGND sg13g2_decap_8
XFILLER_20_498 VPWR VGND sg13g2_decap_8
XFILLER_0_815 VPWR VGND sg13g2_decap_8
XFILLER_47_329 VPWR VGND sg13g2_decap_8
XFILLER_48_819 VPWR VGND sg13g2_decap_4
XFILLER_15_237 VPWR VGND sg13g2_decap_8
XFILLER_16_705 VPWR VGND sg13g2_decap_8
XFILLER_28_543 VPWR VGND sg13g2_decap_8
XFILLER_43_546 VPWR VGND sg13g2_decap_8
XFILLER_11_410 VPWR VGND sg13g2_decap_8
XFILLER_11_454 VPWR VGND sg13g2_decap_8
XFILLER_11_465 VPWR VGND sg13g2_fill_1
XFILLER_23_73 VPWR VGND sg13g2_decap_8
XFILLER_30_207 VPWR VGND sg13g2_decap_8
XFILLER_2_130 VPWR VGND sg13g2_decap_8
XFILLER_7_469 VPWR VGND sg13g2_decap_8
XFILLER_19_532 VPWR VGND sg13g2_decap_8
XFILLER_38_307 VPWR VGND sg13g2_decap_8
X_1040_ state\[56\] net7 VPWR VGND sg13g2_buf_1
Xclkbuf_5_11__f_clk clknet_5_11__leaf_clk clknet_4_5_0_clk VPWR VGND sg13g2_buf_16
XFILLER_48_70 VPWR VGND sg13g2_decap_8
XFILLER_0_77 VPWR VGND sg13g2_decap_8
XFILLER_15_782 VPWR VGND sg13g2_fill_2
XFILLER_21_218 VPWR VGND sg13g2_decap_8
XFILLER_34_502 VPWR VGND sg13g2_decap_8
XFILLER_34_579 VPWR VGND sg13g2_decap_8
XFILLER_9_53 VPWR VGND sg13g2_decap_8
X_0824_ VPWR _0042_ state\[19\] VGND sg13g2_inv_1
X_0755_ _0364_ VPWR _0163_ VGND net88 _0025_ sg13g2_o21ai_1
XFILLER_28_18 VPWR VGND sg13g2_decap_8
XFILLER_29_307 VPWR VGND sg13g2_decap_8
XFILLER_43_0 VPWR VGND sg13g2_decap_8
X_0686_ _0119_ _0424_ _0425_ net47 _0248_ VPWR VGND sg13g2_a22oi_1
XFILLER_25_568 VPWR VGND sg13g2_decap_8
XFILLER_37_384 VPWR VGND sg13g2_decap_8
XFILLER_44_28 VPWR VGND sg13g2_decap_8
XFILLER_20_295 VPWR VGND sg13g2_decap_8
XFILLER_4_417 VPWR VGND sg13g2_decap_8
XFILLER_0_623 VPWR VGND sg13g2_decap_8
XFILLER_28_340 VPWR VGND sg13g2_decap_8
XFILLER_47_126 VPWR VGND sg13g2_decap_8
XFILLER_48_616 VPWR VGND sg13g2_decap_8
XFILLER_16_568 VPWR VGND sg13g2_decap_8
XFILLER_34_61 VPWR VGND sg13g2_decap_8
XFILLER_43_343 VPWR VGND sg13g2_decap_8
XFILLER_11_284 VPWR VGND sg13g2_decap_8
XFILLER_7_266 VPWR VGND sg13g2_decap_8
XFILLER_3_494 VPWR VGND sg13g2_decap_8
X_0540_ _0212_ net63 _0315_ _0316_ VPWR VGND sg13g2_a21o_1
X_0471_ net78 VPWR _0264_ VGND net57 state\[2\] sg13g2_o21ai_1
XFILLER_15_4 VPWR VGND sg13g2_decap_4
XFILLER_38_104 VPWR VGND sg13g2_decap_8
XFILLER_47_693 VPWR VGND sg13g2_decap_8
X_1023_ net111 VGND VPWR _0183_ state\[55\] clknet_5_26__leaf_clk sg13g2_dfrbpq_1
XFILLER_22_538 VPWR VGND sg13g2_decap_8
XFILLER_30_571 VPWR VGND sg13g2_decap_8
XFILLER_34_376 VPWR VGND sg13g2_decap_8
X_0807_ VPWR _0203_ daisychain\[10\] VGND sg13g2_inv_1
X_0738_ _0313_ VPWR _0146_ VGND net85 _0041_ sg13g2_o21ai_1
XFILLER_29_104 VPWR VGND sg13g2_decap_8
XFILLER_39_28 VPWR VGND sg13g2_decap_8
X_0669_ VGND VPWR net28 daisychain\[50\] _0413_ net51 sg13g2_a21oi_1
XFILLER_25_365 VPWR VGND sg13g2_decap_8
XFILLER_26_822 VPWR VGND sg13g2_fill_1
XFILLER_37_181 VPWR VGND sg13g2_decap_8
XFILLER_38_660 VPWR VGND sg13g2_decap_8
XFILLER_21_582 VPWR VGND sg13g2_decap_8
XFILLER_40_357 VPWR VGND sg13g2_decap_8
XFILLER_4_214 VPWR VGND sg13g2_decap_8
XFILLER_0_420 VPWR VGND sg13g2_decap_8
XFILLER_20_85 VPWR VGND sg13g2_decap_8
XFILLER_0_497 VPWR VGND sg13g2_decap_8
XFILLER_17_811 VPWR VGND sg13g2_decap_8
XFILLER_17_822 VPWR VGND sg13g2_fill_1
XFILLER_29_660 VPWR VGND sg13g2_fill_2
XFILLER_29_671 VPWR VGND sg13g2_decap_8
XFILLER_29_682 VPWR VGND sg13g2_fill_2
XFILLER_29_83 VPWR VGND sg13g2_decap_8
XFILLER_44_630 VPWR VGND sg13g2_decap_8
XFILLER_48_413 VPWR VGND sg13g2_decap_8
XFILLER_12_571 VPWR VGND sg13g2_decap_8
XFILLER_16_365 VPWR VGND sg13g2_decap_8
XFILLER_31_368 VPWR VGND sg13g2_decap_8
XFILLER_32_803 VPWR VGND sg13g2_fill_1
XFILLER_43_140 VPWR VGND sg13g2_decap_8
XFILLER_8_531 VPWR VGND sg13g2_decap_8
Xclkbuf_5_9__f_clk clknet_5_9__leaf_clk clknet_4_4_0_clk VPWR VGND sg13g2_buf_16
XFILLER_6_54 VPWR VGND sg13g2_decap_8
XFILLER_39_413 VPWR VGND sg13g2_decap_8
XFILLER_3_291 VPWR VGND sg13g2_decap_8
X_0523_ net84 VPWR _0303_ VGND net62 state\[15\] sg13g2_o21ai_1
X_0454_ VPWR _0020_ state\[60\] VGND sg13g2_inv_1
XFILLER_34_173 VPWR VGND sg13g2_decap_8
XFILLER_47_490 VPWR VGND sg13g2_decap_8
X_1006_ net115 VGND VPWR _0166_ state\[38\] clknet_5_29__leaf_clk sg13g2_dfrbpq_1
XFILLER_22_335 VPWR VGND sg13g2_decap_8
XFILLER_1_217 VPWR VGND sg13g2_decap_8
XFILLER_45_427 VPWR VGND sg13g2_decap_8
XFILLER_13_346 VPWR VGND sg13g2_decap_8
XFILLER_15_41 VPWR VGND sg13g2_decap_8
XFILLER_25_162 VPWR VGND sg13g2_decap_8
XFILLER_40_154 VPWR VGND sg13g2_decap_8
XFILLER_41_644 VPWR VGND sg13g2_decap_4
XFILLER_31_95 VPWR VGND sg13g2_decap_8
XFILLER_5_501 VPWR VGND sg13g2_decap_8
XFILLER_0_294 VPWR VGND sg13g2_decap_8
XFILLER_48_210 VPWR VGND sg13g2_decap_8
XFILLER_49_711 VPWR VGND sg13g2_decap_8
XFILLER_16_162 VPWR VGND sg13g2_decap_8
XFILLER_17_630 VPWR VGND sg13g2_decap_8
XFILLER_36_405 VPWR VGND sg13g2_decap_8
XFILLER_49_788 VPWR VGND sg13g2_decap_8
XFILLER_48_287 VPWR VGND sg13g2_decap_8
XFILLER_20_806 VPWR VGND sg13g2_decap_8
XFILLER_31_165 VPWR VGND sg13g2_decap_8
XFILLER_32_644 VPWR VGND sg13g2_fill_2
XFILLER_32_677 VPWR VGND sg13g2_fill_1
X_0506_ _0074_ _0289_ _0290_ net39 _0203_ VPWR VGND sg13g2_a22oi_1
XFILLER_27_427 VPWR VGND sg13g2_decap_8
XFILLER_39_210 VPWR VGND sg13g2_decap_8
XFILLER_39_287 VPWR VGND sg13g2_decap_8
XFILLER_22_132 VPWR VGND sg13g2_decap_8
XFILLER_23_633 VPWR VGND sg13g2_decap_8
XFILLER_10_349 VPWR VGND sg13g2_decap_8
XFILLER_2_515 VPWR VGND sg13g2_decap_8
Xclkbuf_4_13_0_clk clknet_0_clk clknet_4_13_0_clk VPWR VGND sg13g2_buf_8
XFILLER_18_449 VPWR VGND sg13g2_decap_8
XFILLER_33_419 VPWR VGND sg13g2_decap_8
XFILLER_45_224 VPWR VGND sg13g2_decap_8
XFILLER_46_714 VPWR VGND sg13g2_fill_1
XFILLER_13_143 VPWR VGND sg13g2_decap_8
XFILLER_41_441 VPWR VGND sg13g2_decap_8
XFILLER_9_158 VPWR VGND sg13g2_decap_8
XFILLER_3_11 VPWR VGND sg13g2_decap_8
XFILLER_47_7 VPWR VGND sg13g2_decap_8
XFILLER_5_375 VPWR VGND sg13g2_decap_8
XFILLER_36_202 VPWR VGND sg13g2_decap_8
XFILLER_3_88 VPWR VGND sg13g2_decap_8
XFILLER_49_585 VPWR VGND sg13g2_decap_8
XFILLER_20_603 VPWR VGND sg13g2_decap_8
XFILLER_32_463 VPWR VGND sg13g2_decap_8
XFILLER_36_279 VPWR VGND sg13g2_decap_8
X_0986_ net106 VGND VPWR _0146_ state\[18\] clknet_5_7__leaf_clk sg13g2_dfrbpq_1
XFILLER_47_28 VPWR VGND sg13g2_decap_8
Xfanout104 net118 net104 VPWR VGND sg13g2_buf_1
Xfanout115 net117 net115 VPWR VGND sg13g2_buf_1
XFILLER_15_419 VPWR VGND sg13g2_decap_8
XFILLER_27_224 VPWR VGND sg13g2_decap_8
XFILLER_10_146 VPWR VGND sg13g2_decap_8
XFILLER_12_20 VPWR VGND sg13g2_decap_8
XFILLER_23_430 VPWR VGND sg13g2_decap_8
XFILLER_42_238 VPWR VGND sg13g2_decap_8
XFILLER_6_117 VPWR VGND sg13g2_decap_8
XFILLER_12_97 VPWR VGND sg13g2_decap_8
XFILLER_2_312 VPWR VGND sg13g2_decap_8
XFILLER_2_389 VPWR VGND sg13g2_decap_8
XFILLER_46_511 VPWR VGND sg13g2_decap_8
XFILLER_18_246 VPWR VGND sg13g2_decap_8
XFILLER_27_780 VPWR VGND sg13g2_decap_4
XFILLER_33_216 VPWR VGND sg13g2_decap_8
XFILLER_37_83 VPWR VGND sg13g2_decap_8
XFILLER_46_588 VPWR VGND sg13g2_decap_8
XFILLER_14_496 VPWR VGND sg13g2_decap_8
X_0840_ VPWR _0051_ state\[27\] VGND sg13g2_inv_1
X_0771_ _0412_ VPWR _0179_ VGND net93 _0010_ sg13g2_o21ai_1
XFILLER_6_695 VPWR VGND sg13g2_fill_2
XFILLER_5_172 VPWR VGND sg13g2_decap_8
XFILLER_37_511 VPWR VGND sg13g2_decap_8
XFILLER_37_522 VPWR VGND sg13g2_fill_1
XFILLER_49_382 VPWR VGND sg13g2_decap_8
XFILLER_20_400 VPWR VGND sg13g2_decap_8
XFILLER_32_260 VPWR VGND sg13g2_decap_8
XFILLER_20_477 VPWR VGND sg13g2_decap_8
XFILLER_3_109 VPWR VGND sg13g2_decap_8
X_0969_ net99 VGND VPWR _0129_ state\[1\] clknet_5_8__leaf_clk sg13g2_dfrbpq_1
XFILLER_28_522 VPWR VGND sg13g2_decap_8
XFILLER_47_308 VPWR VGND sg13g2_decap_8
XFILLER_15_216 VPWR VGND sg13g2_decap_8
XFILLER_28_599 VPWR VGND sg13g2_decap_8
XFILLER_43_525 VPWR VGND sg13g2_decap_8
XFILLER_7_448 VPWR VGND sg13g2_decap_8
XFILLER_2_186 VPWR VGND sg13g2_decap_8
XFILLER_0_56 VPWR VGND sg13g2_decap_8
XFILLER_19_511 VPWR VGND sg13g2_decap_8
XFILLER_19_588 VPWR VGND sg13g2_decap_8
XFILLER_46_385 VPWR VGND sg13g2_decap_8
XFILLER_14_293 VPWR VGND sg13g2_decap_8
XFILLER_15_761 VPWR VGND sg13g2_decap_8
XFILLER_34_558 VPWR VGND sg13g2_decap_8
XFILLER_9_32 VPWR VGND sg13g2_decap_8
XFILLER_30_797 VPWR VGND sg13g2_decap_8
X_0823_ VPWR _0211_ daisychain\[18\] VGND sg13g2_inv_1
X_0754_ _0361_ VPWR _0162_ VGND net89 _0022_ sg13g2_o21ai_1
X_0685_ VGND VPWR net29 daisychain\[54\] _0425_ net47 sg13g2_a21oi_1
XFILLER_6_481 VPWR VGND sg13g2_decap_8
XFILLER_25_547 VPWR VGND sg13g2_decap_8
XFILLER_37_363 VPWR VGND sg13g2_decap_8
XFILLER_20_274 VPWR VGND sg13g2_decap_8
XFILLER_33_580 VPWR VGND sg13g2_decap_8
XFILLER_40_539 VPWR VGND sg13g2_decap_8
XFILLER_0_635 VPWR VGND sg13g2_fill_2
XFILLER_0_679 VPWR VGND sg13g2_decap_8
XFILLER_18_85 VPWR VGND sg13g2_decap_8
XFILLER_29_820 VPWR VGND sg13g2_fill_2
XFILLER_44_812 VPWR VGND sg13g2_decap_8
XFILLER_47_105 VPWR VGND sg13g2_decap_8
XFILLER_16_547 VPWR VGND sg13g2_decap_8
XFILLER_28_396 VPWR VGND sg13g2_decap_8
XFILLER_34_40 VPWR VGND sg13g2_decap_8
XFILLER_43_322 VPWR VGND sg13g2_decap_8
XFILLER_43_399 VPWR VGND sg13g2_decap_8
XFILLER_11_263 VPWR VGND sg13g2_decap_8
XFILLER_7_245 VPWR VGND sg13g2_decap_8
XFILLER_3_473 VPWR VGND sg13g2_decap_8
X_0470_ _0065_ _0262_ _0263_ net54 _0194_ VPWR VGND sg13g2_a22oi_1
XFILLER_19_385 VPWR VGND sg13g2_decap_8
XFILLER_22_517 VPWR VGND sg13g2_decap_8
XFILLER_34_355 VPWR VGND sg13g2_decap_8
XFILLER_46_182 VPWR VGND sg13g2_decap_8
XFILLER_47_672 VPWR VGND sg13g2_decap_8
X_1022_ net111 VGND VPWR _0182_ state\[54\] clknet_5_29__leaf_clk sg13g2_dfrbpq_1
XFILLER_15_580 VPWR VGND sg13g2_decap_8
XFILLER_30_550 VPWR VGND sg13g2_decap_8
X_0806_ VPWR _0033_ state\[10\] VGND sg13g2_inv_1
X_0737_ _0310_ VPWR _0145_ VGND net85 _0040_ sg13g2_o21ai_1
X_0668_ _0244_ net71 _0411_ _0412_ VPWR VGND sg13g2_a21o_1
XFILLER_37_160 VPWR VGND sg13g2_decap_8
XFILLER_44_119 VPWR VGND sg13g2_decap_8
XFILLER_45_609 VPWR VGND sg13g2_decap_8
X_0599_ net88 VPWR _0360_ VGND net67 state\[34\] sg13g2_o21ai_1
XFILLER_13_539 VPWR VGND sg13g2_decap_8
XFILLER_25_344 VPWR VGND sg13g2_decap_8
XFILLER_40_336 VPWR VGND sg13g2_decap_8
XFILLER_21_561 VPWR VGND sg13g2_decap_8
XFILLER_0_476 VPWR VGND sg13g2_decap_8
XFILLER_20_64 VPWR VGND sg13g2_decap_8
XFILLER_29_62 VPWR VGND sg13g2_decap_8
XFILLER_16_344 VPWR VGND sg13g2_decap_8
XFILLER_28_193 VPWR VGND sg13g2_decap_8
XFILLER_29_650 VPWR VGND sg13g2_fill_1
XFILLER_48_469 VPWR VGND sg13g2_decap_8
XFILLER_12_550 VPWR VGND sg13g2_decap_8
XFILLER_31_347 VPWR VGND sg13g2_decap_8
XFILLER_43_196 VPWR VGND sg13g2_decap_8
XFILLER_44_686 VPWR VGND sg13g2_decap_4
XFILLER_8_510 VPWR VGND sg13g2_decap_8
XFILLER_3_270 VPWR VGND sg13g2_decap_8
X_0522_ _0078_ _0301_ _0302_ net43 _0207_ VPWR VGND sg13g2_a22oi_1
XFILLER_8_576 VPWR VGND sg13g2_fill_2
XFILLER_6_33 VPWR VGND sg13g2_decap_8
XFILLER_6_11 VPWR VGND sg13g2_decap_8
XFILLER_13_2 VPWR VGND sg13g2_fill_1
XFILLER_27_609 VPWR VGND sg13g2_decap_8
XFILLER_39_469 VPWR VGND sg13g2_decap_8
X_0453_ VPWR _0252_ daisychain\[59\] VGND sg13g2_inv_1
XFILLER_19_182 VPWR VGND sg13g2_decap_8
XFILLER_22_314 VPWR VGND sg13g2_decap_8
XFILLER_23_815 VPWR VGND sg13g2_decap_8
XFILLER_34_152 VPWR VGND sg13g2_decap_8
XFILLER_35_697 VPWR VGND sg13g2_fill_2
X_1005_ net112 VGND VPWR _0165_ state\[37\] clknet_5_27__leaf_clk sg13g2_dfrbpq_1
XFILLER_17_119 VPWR VGND sg13g2_decap_8
XFILLER_25_141 VPWR VGND sg13g2_decap_8
XFILLER_45_406 VPWR VGND sg13g2_decap_8
XFILLER_13_325 VPWR VGND sg13g2_decap_8
XFILLER_15_97 VPWR VGND sg13g2_decap_8
XFILLER_26_686 VPWR VGND sg13g2_decap_8
XFILLER_40_133 VPWR VGND sg13g2_decap_8
XFILLER_41_623 VPWR VGND sg13g2_decap_8
XFILLER_31_74 VPWR VGND sg13g2_decap_8
XFILLER_0_273 VPWR VGND sg13g2_decap_8
XFILLER_49_767 VPWR VGND sg13g2_decap_8
XFILLER_48_266 VPWR VGND sg13g2_decap_8
XFILLER_16_141 VPWR VGND sg13g2_decap_8
XFILLER_44_483 VPWR VGND sg13g2_decap_8
XFILLER_31_144 VPWR VGND sg13g2_decap_8
XFILLER_8_384 VPWR VGND sg13g2_decap_8
X_0505_ VGND VPWR net26 daisychain\[9\] _0290_ net39 sg13g2_a21oi_1
.ends
