* NGSPICE file created from heichips25_pudding.ext - technology: ihp-sg13g2

* Black-box entry subcircuit for sg13g2_decap_8 abstract view
.subckt sg13g2_decap_8 VDD VSS
.ends

* Black-box entry subcircuit for sg13g2_fill_1 abstract view
.subckt sg13g2_fill_1 VDD VSS
.ends

* Black-box entry subcircuit for sg13g2_dfrbpq_1 abstract view
.subckt sg13g2_dfrbpq_1 RESET_B VSS VDD D Q CLK
.ends

* Black-box entry subcircuit for sg13g2_buf_1 abstract view
.subckt sg13g2_buf_1 A X VDD VSS
.ends

* Black-box entry subcircuit for sg13g2_fill_2 abstract view
.subckt sg13g2_fill_2 VDD VSS
.ends

* Black-box entry subcircuit for sg13g2_o21ai_1 abstract view
.subckt sg13g2_o21ai_1 B1 VDD Y VSS A1 A2
.ends

* Black-box entry subcircuit for sg13g2_buf_8 abstract view
.subckt sg13g2_buf_8 A X VDD VSS
.ends

* Black-box entry subcircuit for sg13g2_inv_1 abstract view
.subckt sg13g2_inv_1 VDD Y A VSS
.ends

* Black-box entry subcircuit for sg13g2_decap_4 abstract view
.subckt sg13g2_decap_4 VDD VSS
.ends

* Black-box entry subcircuit for sg13g2_a21o_1 abstract view
.subckt sg13g2_a21o_1 A2 A1 B1 X VDD VSS
.ends

* Black-box entry subcircuit for sg13g2_a22oi_1 abstract view
.subckt sg13g2_a22oi_1 Y B1 B2 A2 A1 VDD VSS
.ends

* Black-box entry subcircuit for sg13g2_a21oi_1 abstract view
.subckt sg13g2_a21oi_1 VSS VDD A1 A2 Y B1
.ends

* Black-box entry subcircuit for sg13g2_buf_16 abstract view
.subckt sg13g2_buf_16 X A VDD VSS
.ends

* Black-box entry subcircuit for sg13g2_or2_1 abstract view
.subckt sg13g2_or2_1 VSS VDD X B A
.ends

* Black-box entry subcircuit for sg13g2_nor2b_1 abstract view
.subckt sg13g2_nor2b_1 A B_N Y VDD VSS
.ends

* Black-box entry subcircuit for sg13g2_nand2_1 abstract view
.subckt sg13g2_nand2_1 Y A B VDD VSS
.ends

* Black-box entry subcircuit for sg13g2_nor2_1 abstract view
.subckt sg13g2_nor2_1 A B Y VDD VSS
.ends

* Black-box entry subcircuit for sg13g2_tiehi abstract view
.subckt sg13g2_tiehi VDD VSS L_HI
.ends

* Black-box entry subcircuit for analog_wires abstract view
.subckt analog_wires VcascP[0] VcascP[1] Iout[0] VDDA[0] VDDA[1] VbiasP[1] VbiasP[0]
+ VcascP[2] VcascP[3] Iout[1] VDDA[2] VDDA[3] VbiasP[3] VbiasP[2] i_in i_out
.ends

* Black-box entry subcircuit for dac32module abstract view
.subckt dac32module EN[1] ENB[1] EN[2] ENB[2] ON[16] ONB[16] ON[17] ONB[17] ON[18]
+ ONB[18] ON[19] ONB[19] ON[20] ONB[20] ON[21] ONB[21] ON[22] ONB[22] ON[23] ONB[23]
+ ON[24] ONB[24] ON[25] ONB[25] ON[26] ONB[26] ON[27] ONB[27] ON[28] ONB[28] ON[29]
+ ONB[29] ON[30] ONB[30] ON[31] ONB[31] EN[3] ENB[3] ON[0] ONB[0] ON[1] ONB[1] ON[2]
+ ONB[2] ON[3] ONB[3] ON[4] ONB[4] ON[5] ONB[5] ON[6] EN[0] ENB[0] ONB[6] ON[7] ONB[7]
+ ON[8] ONB[8] ON[9] ONB[9] ON[10] ONB[10] ON[11] ONB[11] ON[12] ONB[12] ON[13] ONB[13]
+ ON[14] ONB[14] ON[15] ONB[15] Iout VbiasP[0] VbiasP[1] VcascP[1] VcascP[0] VDD VSS
.ends

* Black-box entry subcircuit for sg13g2_antennanp abstract view
.subckt sg13g2_antennanp VDD VSS A
.ends

.subckt heichips25_pudding VGND VPWR clk ena i_in i_out rst_n ui_in[0] ui_in[1] ui_in[2]
+ ui_in[3] ui_in[4] ui_in[5] ui_in[6] ui_in[7] uio_in[0] uio_in[1] uio_in[2] uio_in[3]
+ uio_in[4] uio_in[5] uio_in[6] uio_in[7] uio_oe[0] uio_oe[1] uio_oe[2] uio_oe[3]
+ uio_oe[4] uio_oe[5] uio_oe[6] uio_oe[7] uio_out[0] uio_out[1] uio_out[2] uio_out[3]
+ uio_out[4] uio_out[5] uio_out[6] uio_out[7] uo_out[0] uo_out[1] uo_out[2] uo_out[3]
+ uo_out[4] uo_out[5] uo_out[6] uo_out[7]
XFILLER_39_222 VPWR VGND sg13g2_decap_8
XFILLER_39_299 VPWR VGND sg13g2_decap_8
XFILLER_10_328 VPWR VGND sg13g2_decap_8
XFILLER_22_133 VPWR VGND sg13g2_decap_8
XFILLER_23_645 VPWR VGND sg13g2_decap_8
XFILLER_35_483 VPWR VGND sg13g2_decap_8
XFILLER_7_7 VPWR VGND sg13g2_decap_8
XFILLER_18_406 VPWR VGND sg13g2_decap_8
XFILLER_13_100 VPWR VGND sg13g2_decap_8
XFILLER_26_483 VPWR VGND sg13g2_decap_8
XFILLER_26_63 VPWR VGND sg13g2_decap_8
XFILLER_45_203 VPWR VGND sg13g2_decap_8
XFILLER_13_177 VPWR VGND sg13g2_decap_8
XFILLER_41_475 VPWR VGND sg13g2_decap_8
XFILLER_9_137 VPWR VGND sg13g2_decap_8
XFILLER_1_560 VPWR VGND sg13g2_decap_8
XFILLER_1_571 VPWR VGND sg13g2_fill_1
XFILLER_5_354 VPWR VGND sg13g2_decap_8
XFILLER_36_203 VPWR VGND sg13g2_decap_8
XFILLER_3_67 VPWR VGND sg13g2_decap_8
XFILLER_49_564 VPWR VGND sg13g2_decap_8
XFILLER_20_626 VPWR VGND sg13g2_decap_8
XFILLER_32_431 VPWR VGND sg13g2_decap_8
X_0985_ net106 VGND VPWR _0145_ state\[17\] clknet_5_13__leaf_clk sg13g2_dfrbpq_1
XFILLER_9_693 VPWR VGND sg13g2_decap_8
XFILLER_8_181 VPWR VGND sg13g2_decap_8
XFILLER_28_704 VPWR VGND sg13g2_decap_8
Xfanout105 net108 net105 VPWR VGND sg13g2_buf_1
Xfanout116 net117 net116 VPWR VGND sg13g2_buf_1
XFILLER_27_258 VPWR VGND sg13g2_decap_8
XFILLER_35_280 VPWR VGND sg13g2_decap_8
XFILLER_42_217 VPWR VGND sg13g2_decap_8
XFILLER_10_125 VPWR VGND sg13g2_decap_8
XFILLER_23_442 VPWR VGND sg13g2_decap_8
XFILLER_7_608 VPWR VGND sg13g2_fill_1
XFILLER_12_76 VPWR VGND sg13g2_decap_8
XFILLER_2_368 VPWR VGND sg13g2_decap_8
XFILLER_5_4 VPWR VGND sg13g2_decap_8
XFILLER_18_203 VPWR VGND sg13g2_decap_8
XFILLER_37_84 VPWR VGND sg13g2_decap_8
XFILLER_46_567 VPWR VGND sg13g2_decap_8
XFILLER_14_464 VPWR VGND sg13g2_decap_8
XFILLER_26_280 VPWR VGND sg13g2_decap_8
XFILLER_27_781 VPWR VGND sg13g2_fill_2
XFILLER_33_228 VPWR VGND sg13g2_decap_8
XFILLER_41_272 VPWR VGND sg13g2_decap_8
X_0770_ _0409_ VPWR _0178_ VGND net94 _0009_ sg13g2_o21ai_1
XFILLER_5_151 VPWR VGND sg13g2_decap_8
XFILLER_24_217 VPWR VGND sg13g2_decap_8
XFILLER_37_567 VPWR VGND sg13g2_decap_8
XFILLER_49_361 VPWR VGND sg13g2_decap_8
XFILLER_20_423 VPWR VGND sg13g2_decap_8
X_0968_ net102 VGND VPWR _0128_ state\[0\] clknet_5_1__leaf_clk sg13g2_dfrbpq_1
Xclkbuf_4_12_0_clk clknet_0_clk clknet_4_12_0_clk VPWR VGND sg13g2_buf_8
X_0899_ VPWR _0249_ daisychain\[56\] VGND sg13g2_inv_1
XFILLER_16_707 VPWR VGND sg13g2_fill_2
XFILLER_28_501 VPWR VGND sg13g2_decap_8
XFILLER_28_578 VPWR VGND sg13g2_decap_8
XFILLER_43_504 VPWR VGND sg13g2_decap_8
XFILLER_11_445 VPWR VGND sg13g2_decap_8
XFILLER_23_64 VPWR VGND sg13g2_decap_8
XFILLER_7_427 VPWR VGND sg13g2_decap_8
XFILLER_2_165 VPWR VGND sg13g2_decap_8
XFILLER_0_35 VPWR VGND sg13g2_decap_8
XFILLER_19_501 VPWR VGND sg13g2_decap_8
XFILLER_19_578 VPWR VGND sg13g2_decap_8
XFILLER_34_504 VPWR VGND sg13g2_decap_8
XFILLER_46_364 VPWR VGND sg13g2_decap_8
XFILLER_14_261 VPWR VGND sg13g2_decap_8
XFILLER_42_581 VPWR VGND sg13g2_decap_4
X_0822_ VPWR _0041_ state\[18\] VGND sg13g2_inv_1
XFILLER_9_88 VPWR VGND sg13g2_decap_8
XFILLER_9_11 VPWR VGND sg13g2_decap_8
X_0753_ _0358_ VPWR _0161_ VGND net90 _0011_ sg13g2_o21ai_1
X_0684_ _0248_ net68 _0423_ _0424_ VPWR VGND sg13g2_a21o_1
XFILLER_12_209 VPWR VGND sg13g2_decap_8
XFILLER_25_537 VPWR VGND sg13g2_decap_8
XFILLER_37_364 VPWR VGND sg13g2_decap_8
XFILLER_20_220 VPWR VGND sg13g2_decap_8
XFILLER_20_297 VPWR VGND sg13g2_decap_8
XFILLER_21_787 VPWR VGND sg13g2_fill_2
XFILLER_33_592 VPWR VGND sg13g2_decap_8
XFILLER_0_603 VPWR VGND sg13g2_decap_8
XFILLER_0_636 VPWR VGND sg13g2_fill_1
XFILLER_0_658 VPWR VGND sg13g2_decap_8
XFILLER_16_537 VPWR VGND sg13g2_decap_8
XFILLER_18_42 VPWR VGND sg13g2_decap_8
XFILLER_28_375 VPWR VGND sg13g2_decap_8
XFILLER_29_810 VPWR VGND sg13g2_decap_8
XFILLER_29_821 VPWR VGND sg13g2_fill_2
XFILLER_43_334 VPWR VGND sg13g2_decap_8
XFILLER_11_242 VPWR VGND sg13g2_decap_8
XFILLER_24_581 VPWR VGND sg13g2_decap_8
XFILLER_34_63 VPWR VGND sg13g2_decap_8
XFILLER_3_452 VPWR VGND sg13g2_decap_8
XFILLER_7_224 VPWR VGND sg13g2_decap_8
XFILLER_19_375 VPWR VGND sg13g2_decap_8
XFILLER_22_518 VPWR VGND sg13g2_decap_8
XFILLER_34_301 VPWR VGND sg13g2_decap_8
XFILLER_34_378 VPWR VGND sg13g2_decap_8
XFILLER_46_161 VPWR VGND sg13g2_decap_8
X_1021_ net114 VGND VPWR _0181_ state\[53\] clknet_5_20__leaf_clk sg13g2_dfrbpq_1
XFILLER_47_684 VPWR VGND sg13g2_fill_2
X_0805_ VPWR _0202_ daisychain\[9\] VGND sg13g2_inv_1
X_0736_ _0307_ VPWR _0144_ VGND net84 _0039_ sg13g2_o21ai_1
X_0667_ net88 VPWR _0411_ VGND net67 state\[51\] sg13g2_o21ai_1
X_0598_ _0097_ _0358_ _0359_ net49 _0226_ VPWR VGND sg13g2_a22oi_1
XFILLER_29_139 VPWR VGND sg13g2_decap_8
XFILLER_37_161 VPWR VGND sg13g2_decap_8
XFILLER_21_540 VPWR VGND sg13g2_decap_8
XFILLER_25_345 VPWR VGND sg13g2_decap_8
XFILLER_40_337 VPWR VGND sg13g2_decap_8
XFILLER_4_249 VPWR VGND sg13g2_decap_8
XFILLER_0_455 VPWR VGND sg13g2_decap_8
XFILLER_20_87 VPWR VGND sg13g2_decap_8
XFILLER_29_41 VPWR VGND sg13g2_decap_8
XFILLER_48_448 VPWR VGND sg13g2_decap_8
XFILLER_16_312 VPWR VGND sg13g2_decap_8
XFILLER_16_389 VPWR VGND sg13g2_decap_8
XFILLER_28_172 VPWR VGND sg13g2_decap_8
XFILLER_44_621 VPWR VGND sg13g2_fill_2
XFILLER_44_698 VPWR VGND sg13g2_decap_8
XFILLER_45_84 VPWR VGND sg13g2_decap_8
XFILLER_12_573 VPWR VGND sg13g2_decap_8
XFILLER_31_359 VPWR VGND sg13g2_decap_8
XFILLER_8_566 VPWR VGND sg13g2_decap_8
X_0521_ VGND VPWR net26 daisychain\[13\] _0302_ net40 sg13g2_a21oi_1
X_0452_ VPWR _0019_ state\[59\] VGND sg13g2_inv_1
XFILLER_6_78 VPWR VGND sg13g2_decap_8
XFILLER_19_172 VPWR VGND sg13g2_decap_8
XFILLER_20_4 VPWR VGND sg13g2_decap_8
XFILLER_39_426 VPWR VGND sg13g2_decap_8
XFILLER_22_315 VPWR VGND sg13g2_decap_8
XFILLER_34_175 VPWR VGND sg13g2_decap_8
X_1004_ net110 VGND VPWR _0164_ state\[36\] clknet_5_25__leaf_clk sg13g2_dfrbpq_1
X_0719_ _0127_ _0449_ _0450_ net34 _0256_ VPWR VGND sg13g2_a22oi_1
XFILLER_25_142 VPWR VGND sg13g2_decap_8
XFILLER_26_665 VPWR VGND sg13g2_decap_8
XFILLER_13_359 VPWR VGND sg13g2_decap_8
XFILLER_15_65 VPWR VGND sg13g2_decap_8
XFILLER_40_134 VPWR VGND sg13g2_decap_8
XFILLER_41_657 VPWR VGND sg13g2_fill_1
XFILLER_9_319 VPWR VGND sg13g2_decap_8
XFILLER_31_86 VPWR VGND sg13g2_decap_8
Xoutput7 net7 uio_out[0] VPWR VGND sg13g2_buf_1
Xoutput20 net20 uo_out[5] VPWR VGND sg13g2_buf_1
XFILLER_5_547 VPWR VGND sg13g2_fill_2
XFILLER_5_536 VPWR VGND sg13g2_decap_8
XFILLER_0_252 VPWR VGND sg13g2_decap_8
XFILLER_17_610 VPWR VGND sg13g2_decap_8
XFILLER_48_245 VPWR VGND sg13g2_decap_8
XFILLER_16_186 VPWR VGND sg13g2_decap_8
XFILLER_20_819 VPWR VGND sg13g2_decap_4
XFILLER_31_156 VPWR VGND sg13g2_decap_8
XFILLER_32_613 VPWR VGND sg13g2_decap_8
XFILLER_12_370 VPWR VGND sg13g2_decap_8
Xclkbuf_5_17__f_clk clknet_5_17__leaf_clk clknet_4_8_0_clk VPWR VGND sg13g2_buf_16
XFILLER_8_363 VPWR VGND sg13g2_decap_8
XFILLER_39_201 VPWR VGND sg13g2_decap_8
X_0504_ _0203_ net61 _0288_ _0289_ VPWR VGND sg13g2_a21o_1
XFILLER_23_624 VPWR VGND sg13g2_decap_8
XFILLER_35_462 VPWR VGND sg13g2_decap_8
XFILLER_39_278 VPWR VGND sg13g2_decap_8
XFILLER_10_307 VPWR VGND sg13g2_decap_8
XFILLER_22_112 VPWR VGND sg13g2_decap_8
XFILLER_22_189 VPWR VGND sg13g2_decap_8
XFILLER_13_156 VPWR VGND sg13g2_decap_8
XFILLER_14_646 VPWR VGND sg13g2_fill_1
XFILLER_14_668 VPWR VGND sg13g2_decap_8
XFILLER_26_42 VPWR VGND sg13g2_decap_8
XFILLER_26_462 VPWR VGND sg13g2_decap_8
XFILLER_41_454 VPWR VGND sg13g2_decap_8
XFILLER_45_259 VPWR VGND sg13g2_decap_8
XFILLER_9_116 VPWR VGND sg13g2_decap_8
XFILLER_5_333 VPWR VGND sg13g2_decap_8
XFILLER_3_46 VPWR VGND sg13g2_decap_8
XFILLER_36_259 VPWR VGND sg13g2_decap_8
XFILLER_49_543 VPWR VGND sg13g2_decap_8
XFILLER_17_484 VPWR VGND sg13g2_decap_8
XFILLER_20_605 VPWR VGND sg13g2_decap_8
XFILLER_32_410 VPWR VGND sg13g2_decap_8
XFILLER_32_487 VPWR VGND sg13g2_decap_8
X_0984_ net106 VGND VPWR _0144_ state\[16\] clknet_5_13__leaf_clk sg13g2_dfrbpq_1
XFILLER_8_160 VPWR VGND sg13g2_decap_8
Xfanout106 net107 net106 VPWR VGND sg13g2_buf_1
Xfanout117 net1 net117 VPWR VGND sg13g2_buf_1
XFILLER_23_421 VPWR VGND sg13g2_decap_8
XFILLER_27_237 VPWR VGND sg13g2_decap_8
XFILLER_10_104 VPWR VGND sg13g2_decap_8
XFILLER_12_55 VPWR VGND sg13g2_decap_8
XFILLER_23_498 VPWR VGND sg13g2_decap_8
XFILLER_2_347 VPWR VGND sg13g2_decap_8
XFILLER_18_259 VPWR VGND sg13g2_decap_8
XFILLER_19_727 VPWR VGND sg13g2_fill_1
XFILLER_33_207 VPWR VGND sg13g2_decap_8
XFILLER_37_63 VPWR VGND sg13g2_decap_8
XFILLER_46_546 VPWR VGND sg13g2_decap_8
XFILLER_14_443 VPWR VGND sg13g2_decap_8
XFILLER_41_251 VPWR VGND sg13g2_decap_8
XFILLER_10_660 VPWR VGND sg13g2_fill_1
XFILLER_5_130 VPWR VGND sg13g2_decap_8
XFILLER_49_340 VPWR VGND sg13g2_decap_8
XFILLER_17_281 VPWR VGND sg13g2_decap_8
XFILLER_18_782 VPWR VGND sg13g2_fill_1
XFILLER_18_793 VPWR VGND sg13g2_fill_2
XFILLER_33_730 VPWR VGND sg13g2_decap_4
XFILLER_37_546 VPWR VGND sg13g2_decap_8
XFILLER_20_402 VPWR VGND sg13g2_decap_8
XFILLER_20_479 VPWR VGND sg13g2_decap_8
XFILLER_32_284 VPWR VGND sg13g2_decap_8
X_0967_ net97 VGND VPWR _0127_ daisychain\[63\] clknet_5_10__leaf_clk sg13g2_dfrbpq_1
XFILLER_9_480 VPWR VGND sg13g2_decap_8
X_0898_ VPWR _0016_ state\[56\] VGND sg13g2_inv_1
XFILLER_28_557 VPWR VGND sg13g2_decap_8
XFILLER_11_424 VPWR VGND sg13g2_decap_8
XFILLER_23_295 VPWR VGND sg13g2_decap_8
XFILLER_23_43 VPWR VGND sg13g2_decap_8
XFILLER_24_785 VPWR VGND sg13g2_fill_1
XFILLER_7_406 VPWR VGND sg13g2_decap_8
XFILLER_2_144 VPWR VGND sg13g2_decap_8
XFILLER_48_84 VPWR VGND sg13g2_decap_8
XFILLER_47_822 VPWR VGND sg13g2_fill_1
XFILLER_0_14 VPWR VGND sg13g2_decap_8
XFILLER_14_240 VPWR VGND sg13g2_decap_8
XFILLER_15_752 VPWR VGND sg13g2_decap_8
XFILLER_19_557 VPWR VGND sg13g2_decap_8
XFILLER_46_343 VPWR VGND sg13g2_decap_8
XFILLER_42_560 VPWR VGND sg13g2_decap_8
X_0821_ VPWR _0210_ daisychain\[17\] VGND sg13g2_inv_1
X_0752_ _0355_ VPWR _0160_ VGND net92 _0000_ sg13g2_o21ai_1
XFILLER_9_67 VPWR VGND sg13g2_decap_8
X_0683_ net89 VPWR _0423_ VGND net68 state\[55\] sg13g2_o21ai_1
XFILLER_25_516 VPWR VGND sg13g2_decap_8
XFILLER_37_343 VPWR VGND sg13g2_decap_8
XFILLER_33_571 VPWR VGND sg13g2_decap_8
XFILLER_40_519 VPWR VGND sg13g2_decap_8
XFILLER_20_276 VPWR VGND sg13g2_decap_8
XFILLER_0_615 VPWR VGND sg13g2_decap_4
XFILLER_16_516 VPWR VGND sg13g2_decap_8
XFILLER_18_98 VPWR VGND sg13g2_decap_8
XFILLER_28_354 VPWR VGND sg13g2_decap_8
XFILLER_43_313 VPWR VGND sg13g2_decap_8
XFILLER_11_221 VPWR VGND sg13g2_decap_8
XFILLER_11_298 VPWR VGND sg13g2_decap_8
XFILLER_24_560 VPWR VGND sg13g2_decap_8
XFILLER_34_42 VPWR VGND sg13g2_decap_8
XFILLER_8_737 VPWR VGND sg13g2_decap_4
XFILLER_7_203 VPWR VGND sg13g2_decap_8
XFILLER_3_431 VPWR VGND sg13g2_decap_8
XFILLER_19_354 VPWR VGND sg13g2_decap_8
XFILLER_46_140 VPWR VGND sg13g2_decap_8
XFILLER_47_641 VPWR VGND sg13g2_fill_2
X_1020_ net111 VGND VPWR _0180_ state\[52\] clknet_5_30__leaf_clk sg13g2_dfrbpq_1
Xclkbuf_4_11_0_clk clknet_0_clk clknet_4_11_0_clk VPWR VGND sg13g2_buf_8
XFILLER_15_593 VPWR VGND sg13g2_decap_8
XFILLER_34_357 VPWR VGND sg13g2_decap_8
XFILLER_30_585 VPWR VGND sg13g2_decap_8
X_0804_ VPWR _0063_ state\[9\] VGND sg13g2_inv_1
X_0735_ _0304_ VPWR _0143_ VGND net83 _0038_ sg13g2_o21ai_1
XFILLER_29_118 VPWR VGND sg13g2_decap_8
XFILLER_41_0 VPWR VGND sg13g2_decap_4
X_0666_ _0114_ _0409_ _0410_ net52 _0243_ VPWR VGND sg13g2_a22oi_1
X_0597_ VGND VPWR net27 daisychain\[32\] _0359_ net49 sg13g2_a21oi_1
XFILLER_25_324 VPWR VGND sg13g2_decap_8
XFILLER_37_140 VPWR VGND sg13g2_decap_8
XFILLER_38_652 VPWR VGND sg13g2_fill_1
XFILLER_38_685 VPWR VGND sg13g2_decap_4
XFILLER_21_596 VPWR VGND sg13g2_decap_8
XFILLER_40_316 VPWR VGND sg13g2_decap_8
XFILLER_20_11 VPWR VGND sg13g2_decap_8
XFILLER_20_66 VPWR VGND sg13g2_decap_8
XFILLER_4_228 VPWR VGND sg13g2_decap_8
XFILLER_0_434 VPWR VGND sg13g2_decap_8
XFILLER_29_20 VPWR VGND sg13g2_decap_8
XFILLER_29_97 VPWR VGND sg13g2_decap_8
XFILLER_48_427 VPWR VGND sg13g2_decap_8
XFILLER_16_368 VPWR VGND sg13g2_decap_8
XFILLER_28_151 VPWR VGND sg13g2_decap_8
XFILLER_29_685 VPWR VGND sg13g2_decap_8
XFILLER_31_338 VPWR VGND sg13g2_decap_8
XFILLER_43_165 VPWR VGND sg13g2_decap_8
XFILLER_45_63 VPWR VGND sg13g2_decap_8
XFILLER_12_552 VPWR VGND sg13g2_decap_8
XFILLER_8_545 VPWR VGND sg13g2_decap_8
XFILLER_6_57 VPWR VGND sg13g2_decap_8
XFILLER_39_405 VPWR VGND sg13g2_decap_8
X_0520_ _0207_ net62 _0300_ _0301_ VPWR VGND sg13g2_a21o_1
XFILLER_13_4 VPWR VGND sg13g2_fill_1
XFILLER_19_151 VPWR VGND sg13g2_decap_8
XFILLER_35_644 VPWR VGND sg13g2_fill_2
XFILLER_39_449 VPWR VGND sg13g2_decap_8
X_1003_ net109 VGND VPWR _0163_ state\[35\] clknet_5_25__leaf_clk sg13g2_dfrbpq_1
XFILLER_30_382 VPWR VGND sg13g2_decap_8
XFILLER_34_154 VPWR VGND sg13g2_decap_8
X_0718_ VGND VPWR net33 daisychain\[62\] _0450_ net34 sg13g2_a21oi_1
X_0649_ VGND VPWR net28 daisychain\[45\] _0398_ net50 sg13g2_a21oi_1
XFILLER_13_338 VPWR VGND sg13g2_decap_8
XFILLER_14_817 VPWR VGND sg13g2_decap_4
XFILLER_15_44 VPWR VGND sg13g2_decap_8
XFILLER_25_121 VPWR VGND sg13g2_decap_8
XFILLER_25_198 VPWR VGND sg13g2_decap_8
XFILLER_26_644 VPWR VGND sg13g2_decap_8
XFILLER_40_113 VPWR VGND sg13g2_decap_8
XFILLER_21_393 VPWR VGND sg13g2_decap_8
XFILLER_31_65 VPWR VGND sg13g2_decap_8
XFILLER_5_515 VPWR VGND sg13g2_decap_8
XFILLER_0_231 VPWR VGND sg13g2_decap_8
XFILLER_1_787 VPWR VGND sg13g2_fill_1
Xoutput8 net8 uio_out[1] VPWR VGND sg13g2_buf_1
Xoutput21 net21 uo_out[6] VPWR VGND sg13g2_buf_1
Xoutput10 net10 uio_out[3] VPWR VGND sg13g2_buf_1
XFILLER_29_482 VPWR VGND sg13g2_decap_8
XFILLER_49_758 VPWR VGND sg13g2_decap_8
XFILLER_48_224 VPWR VGND sg13g2_decap_8
XFILLER_16_165 VPWR VGND sg13g2_decap_8
XFILLER_31_135 VPWR VGND sg13g2_decap_8
XFILLER_32_669 VPWR VGND sg13g2_decap_8
XFILLER_8_342 VPWR VGND sg13g2_decap_8
XFILLER_39_257 VPWR VGND sg13g2_decap_8
X_0503_ net82 VPWR _0288_ VGND net61 state\[10\] sg13g2_o21ai_1
XFILLER_23_603 VPWR VGND sg13g2_decap_8
XFILLER_27_419 VPWR VGND sg13g2_decap_8
XFILLER_35_441 VPWR VGND sg13g2_decap_8
XFILLER_22_168 VPWR VGND sg13g2_decap_8
XFILLER_2_529 VPWR VGND sg13g2_decap_8
XFILLER_45_238 VPWR VGND sg13g2_decap_8
XFILLER_46_739 VPWR VGND sg13g2_fill_2
Xclkbuf_5_23__f_clk clknet_5_23__leaf_clk clknet_4_11_0_clk VPWR VGND sg13g2_buf_16
XFILLER_13_135 VPWR VGND sg13g2_decap_8
XFILLER_26_441 VPWR VGND sg13g2_decap_8
XFILLER_26_98 VPWR VGND sg13g2_decap_8
XFILLER_41_433 VPWR VGND sg13g2_decap_8
XFILLER_21_190 VPWR VGND sg13g2_decap_8
XFILLER_42_86 VPWR VGND sg13g2_decap_8
XFILLER_5_389 VPWR VGND sg13g2_decap_8
XFILLER_5_312 VPWR VGND sg13g2_decap_8
XFILLER_3_25 VPWR VGND sg13g2_decap_8
XFILLER_49_522 VPWR VGND sg13g2_decap_8
XFILLER_17_463 VPWR VGND sg13g2_decap_8
XFILLER_36_238 VPWR VGND sg13g2_decap_8
XFILLER_44_282 VPWR VGND sg13g2_decap_8
XFILLER_49_599 VPWR VGND sg13g2_decap_8
XFILLER_32_466 VPWR VGND sg13g2_decap_8
X_0983_ net105 VGND VPWR _0143_ state\[15\] clknet_5_5__leaf_clk sg13g2_dfrbpq_1
XFILLER_9_662 VPWR VGND sg13g2_decap_8
Xfanout107 net108 net107 VPWR VGND sg13g2_buf_1
XFILLER_27_216 VPWR VGND sg13g2_decap_8
XFILLER_28_739 VPWR VGND sg13g2_decap_4
XFILLER_11_606 VPWR VGND sg13g2_fill_2
XFILLER_11_617 VPWR VGND sg13g2_fill_2
XFILLER_23_400 VPWR VGND sg13g2_decap_8
XFILLER_23_477 VPWR VGND sg13g2_decap_8
XFILLER_12_34 VPWR VGND sg13g2_decap_8
XFILLER_2_326 VPWR VGND sg13g2_decap_8
XFILLER_14_422 VPWR VGND sg13g2_decap_8
XFILLER_18_238 VPWR VGND sg13g2_decap_8
XFILLER_37_42 VPWR VGND sg13g2_decap_8
XFILLER_46_525 VPWR VGND sg13g2_decap_8
XFILLER_14_499 VPWR VGND sg13g2_decap_8
XFILLER_41_230 VPWR VGND sg13g2_decap_8
XFILLER_45_7 VPWR VGND sg13g2_decap_8
XFILLER_5_186 VPWR VGND sg13g2_decap_8
XFILLER_1_392 VPWR VGND sg13g2_decap_8
XFILLER_37_525 VPWR VGND sg13g2_decap_8
XFILLER_49_396 VPWR VGND sg13g2_decap_8
XFILLER_17_260 VPWR VGND sg13g2_decap_8
XFILLER_32_263 VPWR VGND sg13g2_decap_8
XFILLER_20_458 VPWR VGND sg13g2_decap_8
X_0897_ VPWR _0248_ daisychain\[55\] VGND sg13g2_inv_1
X_0966_ net97 VGND VPWR _0126_ daisychain\[62\] clknet_5_2__leaf_clk sg13g2_dfrbpq_1
XFILLER_0_819 VPWR VGND sg13g2_decap_4
XFILLER_15_219 VPWR VGND sg13g2_decap_8
XFILLER_28_536 VPWR VGND sg13g2_decap_8
XFILLER_43_539 VPWR VGND sg13g2_decap_8
XFILLER_11_403 VPWR VGND sg13g2_decap_8
XFILLER_23_11 VPWR VGND sg13g2_decap_8
XFILLER_23_274 VPWR VGND sg13g2_decap_8
XFILLER_23_99 VPWR VGND sg13g2_decap_8
XFILLER_2_123 VPWR VGND sg13g2_decap_8
XFILLER_19_536 VPWR VGND sg13g2_decap_8
XFILLER_46_322 VPWR VGND sg13g2_decap_8
XFILLER_48_63 VPWR VGND sg13g2_decap_8
XFILLER_47_801 VPWR VGND sg13g2_fill_1
XFILLER_27_580 VPWR VGND sg13g2_decap_8
XFILLER_34_539 VPWR VGND sg13g2_decap_8
XFILLER_46_399 VPWR VGND sg13g2_decap_8
XFILLER_14_296 VPWR VGND sg13g2_decap_8
XFILLER_30_778 VPWR VGND sg13g2_decap_8
X_0820_ VPWR _0040_ state\[17\] VGND sg13g2_inv_1
X_0751_ _0352_ VPWR _0159_ VGND net86 _0056_ sg13g2_o21ai_1
XFILLER_9_46 VPWR VGND sg13g2_decap_8
X_0682_ _0118_ _0421_ _0422_ net48 _0247_ VPWR VGND sg13g2_a22oi_1
XFILLER_6_484 VPWR VGND sg13g2_decap_8
XFILLER_37_322 VPWR VGND sg13g2_decap_8
XFILLER_37_399 VPWR VGND sg13g2_decap_8
XFILLER_49_193 VPWR VGND sg13g2_decap_8
XFILLER_20_255 VPWR VGND sg13g2_decap_8
XFILLER_21_701 VPWR VGND sg13g2_fill_2
XFILLER_33_550 VPWR VGND sg13g2_decap_8
X_0949_ net112 VGND VPWR _0109_ daisychain\[45\] clknet_5_19__leaf_clk sg13g2_dfrbpq_1
XFILLER_0_627 VPWR VGND sg13g2_decap_8
XFILLER_28_333 VPWR VGND sg13g2_decap_8
XFILLER_47_119 VPWR VGND sg13g2_decap_8
XFILLER_48_609 VPWR VGND sg13g2_decap_8
XFILLER_18_77 VPWR VGND sg13g2_decap_8
XFILLER_34_21 VPWR VGND sg13g2_decap_8
XFILLER_43_369 VPWR VGND sg13g2_decap_8
XFILLER_11_200 VPWR VGND sg13g2_decap_8
XFILLER_11_277 VPWR VGND sg13g2_decap_8
XFILLER_34_98 VPWR VGND sg13g2_decap_8
XFILLER_7_259 VPWR VGND sg13g2_decap_8
XFILLER_1_0 VPWR VGND sg13g2_decap_8
XFILLER_3_410 VPWR VGND sg13g2_decap_8
XFILLER_3_487 VPWR VGND sg13g2_decap_8
XFILLER_19_333 VPWR VGND sg13g2_decap_8
XFILLER_38_119 VPWR VGND sg13g2_decap_8
XFILLER_30_564 VPWR VGND sg13g2_decap_8
XFILLER_34_336 VPWR VGND sg13g2_decap_8
XFILLER_46_196 VPWR VGND sg13g2_decap_8
X_0803_ VPWR _0201_ daisychain\[8\] VGND sg13g2_inv_1
X_0734_ _0301_ VPWR _0142_ VGND net83 _0037_ sg13g2_o21ai_1
X_0665_ VGND VPWR net29 daisychain\[49\] _0410_ net52 sg13g2_a21oi_1
XFILLER_6_281 VPWR VGND sg13g2_decap_8
XFILLER_34_0 VPWR VGND sg13g2_decap_8
X_0596_ _0226_ net69 _0357_ _0358_ VPWR VGND sg13g2_a21o_1
XFILLER_1_91 VPWR VGND sg13g2_decap_8
XFILLER_25_303 VPWR VGND sg13g2_decap_8
XFILLER_37_196 VPWR VGND sg13g2_decap_8
Xclkbuf_5_4__f_clk clknet_5_4__leaf_clk clknet_4_2_0_clk VPWR VGND sg13g2_buf_16
XFILLER_21_575 VPWR VGND sg13g2_decap_8
XFILLER_0_413 VPWR VGND sg13g2_decap_8
XFILLER_20_45 VPWR VGND sg13g2_decap_8
XFILLER_4_207 VPWR VGND sg13g2_decap_8
XFILLER_28_130 VPWR VGND sg13g2_decap_8
XFILLER_29_664 VPWR VGND sg13g2_decap_8
XFILLER_29_76 VPWR VGND sg13g2_decap_8
XFILLER_48_406 VPWR VGND sg13g2_decap_8
XFILLER_12_531 VPWR VGND sg13g2_decap_8
XFILLER_16_347 VPWR VGND sg13g2_decap_8
XFILLER_31_317 VPWR VGND sg13g2_decap_8
XFILLER_43_144 VPWR VGND sg13g2_decap_8
XFILLER_44_634 VPWR VGND sg13g2_decap_4
XFILLER_45_42 VPWR VGND sg13g2_decap_8
XFILLER_8_524 VPWR VGND sg13g2_decap_8
XFILLER_6_36 VPWR VGND sg13g2_decap_8
XFILLER_6_25 VPWR VGND sg13g2_fill_1
XFILLER_3_284 VPWR VGND sg13g2_decap_8
XFILLER_19_130 VPWR VGND sg13g2_decap_8
XFILLER_34_133 VPWR VGND sg13g2_decap_8
XFILLER_35_623 VPWR VGND sg13g2_decap_8
XFILLER_47_483 VPWR VGND sg13g2_decap_8
X_1002_ net109 VGND VPWR _0162_ state\[34\] clknet_5_28__leaf_clk sg13g2_dfrbpq_1
XFILLER_15_380 VPWR VGND sg13g2_decap_8
XFILLER_30_361 VPWR VGND sg13g2_decap_8
X_0717_ _0256_ net55 _0448_ _0449_ VPWR VGND sg13g2_a21o_1
X_0648_ _0239_ net71 _0396_ _0397_ VPWR VGND sg13g2_a21o_1
XFILLER_26_623 VPWR VGND sg13g2_decap_8
XFILLER_38_483 VPWR VGND sg13g2_decap_8
X_0579_ net81 VPWR _0345_ VGND net60 state\[29\] sg13g2_o21ai_1
XFILLER_13_317 VPWR VGND sg13g2_decap_8
XFILLER_25_100 VPWR VGND sg13g2_decap_8
XFILLER_25_177 VPWR VGND sg13g2_decap_8
XFILLER_41_648 VPWR VGND sg13g2_decap_8
XFILLER_21_372 VPWR VGND sg13g2_decap_8
XFILLER_31_11 VPWR VGND sg13g2_fill_1
XFILLER_31_44 VPWR VGND sg13g2_decap_8
XFILLER_40_169 VPWR VGND sg13g2_decap_8
Xclkbuf_4_10_0_clk clknet_0_clk clknet_4_10_0_clk VPWR VGND sg13g2_buf_8
XFILLER_0_210 VPWR VGND sg13g2_decap_8
XFILLER_0_287 VPWR VGND sg13g2_decap_8
Xoutput9 net9 uio_out[2] VPWR VGND sg13g2_buf_1
Xoutput22 net22 uo_out[7] VPWR VGND sg13g2_buf_1
Xoutput11 net11 uio_out[4] VPWR VGND sg13g2_buf_1
XFILLER_49_748 VPWR VGND sg13g2_decap_4
XFILLER_48_203 VPWR VGND sg13g2_decap_8
XFILLER_16_144 VPWR VGND sg13g2_decap_8
XFILLER_17_645 VPWR VGND sg13g2_decap_8
XFILLER_29_461 VPWR VGND sg13g2_decap_8
XFILLER_44_464 VPWR VGND sg13g2_decap_4
XFILLER_31_114 VPWR VGND sg13g2_decap_8
XFILLER_32_648 VPWR VGND sg13g2_decap_8
XFILLER_44_486 VPWR VGND sg13g2_decap_8
XFILLER_8_321 VPWR VGND sg13g2_decap_8
X_0502_ _0073_ _0286_ _0287_ net40 _0202_ VPWR VGND sg13g2_a22oi_1
XFILLER_8_398 VPWR VGND sg13g2_decap_8
XFILLER_39_236 VPWR VGND sg13g2_decap_8
XFILLER_22_147 VPWR VGND sg13g2_decap_8
XFILLER_23_659 VPWR VGND sg13g2_decap_8
XFILLER_35_420 VPWR VGND sg13g2_decap_8
XFILLER_35_497 VPWR VGND sg13g2_decap_8
XFILLER_47_280 VPWR VGND sg13g2_decap_8
XFILLER_31_681 VPWR VGND sg13g2_fill_2
XFILLER_2_508 VPWR VGND sg13g2_decap_8
XFILLER_14_604 VPWR VGND sg13g2_decap_8
XFILLER_26_11 VPWR VGND sg13g2_fill_2
XFILLER_26_420 VPWR VGND sg13g2_decap_8
XFILLER_38_280 VPWR VGND sg13g2_decap_8
XFILLER_45_217 VPWR VGND sg13g2_decap_8
XFILLER_13_114 VPWR VGND sg13g2_decap_8
XFILLER_26_497 VPWR VGND sg13g2_decap_8
XFILLER_26_77 VPWR VGND sg13g2_decap_8
XFILLER_41_412 VPWR VGND sg13g2_decap_8
XFILLER_41_489 VPWR VGND sg13g2_decap_8
XFILLER_42_32 VPWR VGND sg13g2_fill_1
XFILLER_42_65 VPWR VGND sg13g2_decap_8
XFILLER_5_368 VPWR VGND sg13g2_decap_8
XFILLER_1_585 VPWR VGND sg13g2_fill_2
XFILLER_36_217 VPWR VGND sg13g2_decap_8
XFILLER_49_578 VPWR VGND sg13g2_decap_8
XFILLER_49_501 VPWR VGND sg13g2_decap_8
XFILLER_17_442 VPWR VGND sg13g2_decap_8
XFILLER_32_445 VPWR VGND sg13g2_decap_8
XFILLER_44_261 VPWR VGND sg13g2_decap_8
X_0982_ net105 VGND VPWR _0142_ state\[14\] clknet_5_7__leaf_clk sg13g2_dfrbpq_1
XFILLER_8_195 VPWR VGND sg13g2_decap_8
Xfanout108 net116 net108 VPWR VGND sg13g2_buf_1
XFILLER_28_718 VPWR VGND sg13g2_decap_8
XFILLER_10_139 VPWR VGND sg13g2_decap_8
XFILLER_11_629 VPWR VGND sg13g2_fill_2
XFILLER_23_456 VPWR VGND sg13g2_decap_8
XFILLER_35_294 VPWR VGND sg13g2_decap_8
XFILLER_12_13 VPWR VGND sg13g2_decap_8
XFILLER_2_305 VPWR VGND sg13g2_decap_8
XFILLER_19_718 VPWR VGND sg13g2_fill_2
XFILLER_37_21 VPWR VGND sg13g2_decap_8
XFILLER_46_504 VPWR VGND sg13g2_decap_8
XFILLER_14_401 VPWR VGND sg13g2_decap_8
XFILLER_18_217 VPWR VGND sg13g2_decap_8
XFILLER_26_294 VPWR VGND sg13g2_decap_8
XFILLER_37_98 VPWR VGND sg13g2_decap_8
XFILLER_42_732 VPWR VGND sg13g2_decap_4
XFILLER_14_478 VPWR VGND sg13g2_decap_8
XFILLER_41_286 VPWR VGND sg13g2_decap_8
XFILLER_1_371 VPWR VGND sg13g2_decap_8
XFILLER_38_7 VPWR VGND sg13g2_decap_8
XFILLER_5_165 VPWR VGND sg13g2_decap_8
XFILLER_37_504 VPWR VGND sg13g2_decap_8
XFILLER_49_375 VPWR VGND sg13g2_decap_8
XFILLER_18_773 VPWR VGND sg13g2_decap_8
XFILLER_20_437 VPWR VGND sg13g2_decap_8
XFILLER_32_242 VPWR VGND sg13g2_decap_8
XFILLER_33_798 VPWR VGND sg13g2_decap_8
XFILLER_45_581 VPWR VGND sg13g2_decap_8
X_0896_ VPWR _0015_ state\[55\] VGND sg13g2_inv_1
X_0965_ net97 VGND VPWR _0125_ daisychain\[61\] clknet_5_10__leaf_clk sg13g2_dfrbpq_1
XFILLER_28_515 VPWR VGND sg13g2_decap_8
XFILLER_36_581 VPWR VGND sg13g2_decap_8
XFILLER_43_518 VPWR VGND sg13g2_decap_8
XFILLER_11_459 VPWR VGND sg13g2_decap_8
XFILLER_23_253 VPWR VGND sg13g2_decap_8
XFILLER_23_78 VPWR VGND sg13g2_decap_8
XFILLER_2_102 VPWR VGND sg13g2_decap_8
XFILLER_2_179 VPWR VGND sg13g2_decap_8
XFILLER_3_4 VPWR VGND sg13g2_decap_8
XFILLER_3_603 VPWR VGND sg13g2_fill_1
XFILLER_0_49 VPWR VGND sg13g2_decap_8
XFILLER_19_515 VPWR VGND sg13g2_decap_8
XFILLER_46_301 VPWR VGND sg13g2_decap_8
XFILLER_48_42 VPWR VGND sg13g2_decap_8
XFILLER_47_813 VPWR VGND sg13g2_decap_8
XFILLER_14_275 VPWR VGND sg13g2_decap_8
XFILLER_15_787 VPWR VGND sg13g2_decap_4
XFILLER_15_798 VPWR VGND sg13g2_fill_1
XFILLER_34_518 VPWR VGND sg13g2_decap_8
XFILLER_46_378 VPWR VGND sg13g2_decap_8
XFILLER_9_25 VPWR VGND sg13g2_decap_8
Xfanout90 net95 net90 VPWR VGND sg13g2_buf_1
X_0750_ _0349_ VPWR _0158_ VGND net87 _0055_ sg13g2_o21ai_1
X_0681_ VGND VPWR net30 daisychain\[53\] _0422_ net49 sg13g2_a21oi_1
XFILLER_6_463 VPWR VGND sg13g2_decap_8
XFILLER_18_581 VPWR VGND sg13g2_decap_8
XFILLER_37_301 VPWR VGND sg13g2_decap_8
XFILLER_37_378 VPWR VGND sg13g2_decap_8
XFILLER_49_172 VPWR VGND sg13g2_decap_8
XFILLER_20_234 VPWR VGND sg13g2_decap_8
XFILLER_21_724 VPWR VGND sg13g2_fill_1
X_0948_ net112 VGND VPWR _0108_ daisychain\[44\] clknet_5_18__leaf_clk sg13g2_dfrbpq_1
X_0879_ VPWR _0239_ daisychain\[46\] VGND sg13g2_inv_1
XFILLER_18_56 VPWR VGND sg13g2_decap_8
XFILLER_28_312 VPWR VGND sg13g2_decap_8
XFILLER_24_595 VPWR VGND sg13g2_decap_8
XFILLER_28_389 VPWR VGND sg13g2_decap_8
XFILLER_34_77 VPWR VGND sg13g2_decap_8
XFILLER_43_348 VPWR VGND sg13g2_decap_8
XFILLER_11_256 VPWR VGND sg13g2_decap_8
XFILLER_7_238 VPWR VGND sg13g2_decap_8
XFILLER_3_466 VPWR VGND sg13g2_decap_8
XFILLER_19_312 VPWR VGND sg13g2_decap_8
XFILLER_19_389 VPWR VGND sg13g2_decap_8
XFILLER_34_315 VPWR VGND sg13g2_decap_8
XFILLER_46_175 VPWR VGND sg13g2_decap_8
XFILLER_47_676 VPWR VGND sg13g2_fill_1
XFILLER_30_543 VPWR VGND sg13g2_decap_8
XFILLER_42_392 VPWR VGND sg13g2_decap_8
X_0802_ VPWR _0062_ state\[8\] VGND sg13g2_inv_1
X_0733_ _0298_ VPWR _0141_ VGND net82 _0036_ sg13g2_o21ai_1
X_0664_ _0243_ net72 _0408_ _0409_ VPWR VGND sg13g2_a21o_1
XFILLER_6_260 VPWR VGND sg13g2_decap_8
XFILLER_27_0 VPWR VGND sg13g2_decap_8
X_0595_ net90 VPWR _0357_ VGND net69 state\[33\] sg13g2_o21ai_1
XFILLER_1_70 VPWR VGND sg13g2_decap_8
XFILLER_25_359 VPWR VGND sg13g2_decap_8
XFILLER_37_175 VPWR VGND sg13g2_decap_8
XFILLER_20_24 VPWR VGND sg13g2_decap_8
XFILLER_21_554 VPWR VGND sg13g2_decap_8
XFILLER_0_469 VPWR VGND sg13g2_decap_8
XFILLER_16_326 VPWR VGND sg13g2_decap_8
XFILLER_17_805 VPWR VGND sg13g2_fill_1
XFILLER_17_816 VPWR VGND sg13g2_decap_8
XFILLER_28_186 VPWR VGND sg13g2_decap_8
XFILLER_29_55 VPWR VGND sg13g2_decap_8
XFILLER_29_643 VPWR VGND sg13g2_decap_8
XFILLER_43_123 VPWR VGND sg13g2_decap_8
XFILLER_45_21 VPWR VGND sg13g2_decap_8
Xdigitalen.g\[2\].u.inv1 VPWR digitalen.g\[2\].u.OUTN net6 VGND sg13g2_inv_1
XFILLER_12_510 VPWR VGND sg13g2_decap_8
XFILLER_12_587 VPWR VGND sg13g2_decap_8
XFILLER_24_392 VPWR VGND sg13g2_decap_8
XFILLER_45_98 VPWR VGND sg13g2_decap_8
XFILLER_8_503 VPWR VGND sg13g2_decap_8
XFILLER_3_263 VPWR VGND sg13g2_decap_8
XFILLER_10_90 VPWR VGND sg13g2_decap_8
XFILLER_19_186 VPWR VGND sg13g2_decap_8
XFILLER_22_329 VPWR VGND sg13g2_decap_8
XFILLER_34_112 VPWR VGND sg13g2_decap_8
XFILLER_34_189 VPWR VGND sg13g2_decap_8
XFILLER_35_602 VPWR VGND sg13g2_decap_8
XFILLER_35_646 VPWR VGND sg13g2_fill_1
XFILLER_47_462 VPWR VGND sg13g2_decap_8
X_1001_ net111 VGND VPWR _0161_ state\[33\] clknet_5_29__leaf_clk sg13g2_dfrbpq_1
XFILLER_30_340 VPWR VGND sg13g2_decap_8
X_0716_ net77 VPWR _0448_ VGND net55 state\[63\] sg13g2_o21ai_1
X_0647_ net91 VPWR _0396_ VGND net74 state\[46\] sg13g2_o21ai_1
X_0578_ _0092_ _0343_ _0344_ net39 _0221_ VPWR VGND sg13g2_a22oi_1
XFILLER_7_591 VPWR VGND sg13g2_fill_1
XFILLER_26_602 VPWR VGND sg13g2_decap_8
XFILLER_38_462 VPWR VGND sg13g2_decap_8
XFILLER_15_79 VPWR VGND sg13g2_decap_8
XFILLER_21_351 VPWR VGND sg13g2_decap_8
XFILLER_25_156 VPWR VGND sg13g2_decap_8
XFILLER_26_679 VPWR VGND sg13g2_decap_8
XFILLER_40_148 VPWR VGND sg13g2_decap_8
XFILLER_41_616 VPWR VGND sg13g2_fill_2
XFILLER_41_638 VPWR VGND sg13g2_decap_4
XFILLER_31_23 VPWR VGND sg13g2_decap_8
Xoutput12 net12 uio_out[5] VPWR VGND sg13g2_buf_1
XFILLER_0_266 VPWR VGND sg13g2_decap_8
XFILLER_29_440 VPWR VGND sg13g2_decap_8
XFILLER_49_705 VPWR VGND sg13g2_decap_8
XFILLER_48_259 VPWR VGND sg13g2_decap_8
XFILLER_16_123 VPWR VGND sg13g2_decap_8
XFILLER_17_624 VPWR VGND sg13g2_decap_8
XFILLER_32_627 VPWR VGND sg13g2_decap_8
XFILLER_44_443 VPWR VGND sg13g2_decap_8
XFILLER_12_384 VPWR VGND sg13g2_decap_8
XFILLER_8_377 VPWR VGND sg13g2_decap_8
XFILLER_8_300 VPWR VGND sg13g2_decap_8
X_0501_ VGND VPWR net23 daisychain\[8\] _0287_ net37 sg13g2_a21oi_1
XFILLER_39_215 VPWR VGND sg13g2_decap_8
XFILLER_22_126 VPWR VGND sg13g2_decap_8
XFILLER_23_638 VPWR VGND sg13g2_decap_8
XFILLER_31_660 VPWR VGND sg13g2_decap_8
XFILLER_35_476 VPWR VGND sg13g2_decap_8
XFILLER_7_91 VPWR VGND sg13g2_decap_8
XFILLER_26_476 VPWR VGND sg13g2_decap_8
XFILLER_26_56 VPWR VGND sg13g2_decap_8
XFILLER_22_693 VPWR VGND sg13g2_fill_2
XFILLER_41_468 VPWR VGND sg13g2_decap_8
XFILLER_1_553 VPWR VGND sg13g2_decap_8
XFILLER_5_347 VPWR VGND sg13g2_decap_8
XFILLER_17_421 VPWR VGND sg13g2_decap_8
XFILLER_37_708 VPWR VGND sg13g2_decap_4
XFILLER_49_557 VPWR VGND sg13g2_decap_8
XFILLER_17_498 VPWR VGND sg13g2_decap_8
XFILLER_20_619 VPWR VGND sg13g2_decap_8
XFILLER_32_424 VPWR VGND sg13g2_decap_8
XFILLER_44_240 VPWR VGND sg13g2_decap_8
X_0981_ net104 VGND VPWR _0141_ state\[13\] clknet_5_4__leaf_clk sg13g2_dfrbpq_1
XFILLER_12_181 VPWR VGND sg13g2_decap_8
XFILLER_9_686 VPWR VGND sg13g2_fill_2
XFILLER_9_642 VPWR VGND sg13g2_fill_1
XFILLER_8_174 VPWR VGND sg13g2_decap_8
Xfanout109 net110 net109 VPWR VGND sg13g2_buf_1
XFILLER_35_273 VPWR VGND sg13g2_decap_8
XFILLER_10_118 VPWR VGND sg13g2_decap_8
XFILLER_11_608 VPWR VGND sg13g2_fill_1
XFILLER_11_619 VPWR VGND sg13g2_fill_1
XFILLER_23_435 VPWR VGND sg13g2_decap_8
XFILLER_12_69 VPWR VGND sg13g2_decap_8
XFILLER_39_590 VPWR VGND sg13g2_decap_8
XFILLER_14_457 VPWR VGND sg13g2_decap_8
XFILLER_26_273 VPWR VGND sg13g2_decap_8
XFILLER_27_741 VPWR VGND sg13g2_fill_1
XFILLER_27_774 VPWR VGND sg13g2_decap_8
XFILLER_27_796 VPWR VGND sg13g2_decap_4
XFILLER_37_77 VPWR VGND sg13g2_decap_8
XFILLER_41_265 VPWR VGND sg13g2_decap_8
XFILLER_10_696 VPWR VGND sg13g2_decap_4
XFILLER_22_490 VPWR VGND sg13g2_decap_8
XFILLER_5_144 VPWR VGND sg13g2_decap_8
XFILLER_1_350 VPWR VGND sg13g2_decap_8
XFILLER_33_700 VPWR VGND sg13g2_decap_8
XFILLER_33_711 VPWR VGND sg13g2_fill_2
XFILLER_45_560 VPWR VGND sg13g2_decap_8
XFILLER_49_354 VPWR VGND sg13g2_decap_8
XFILLER_17_295 VPWR VGND sg13g2_decap_8
XFILLER_20_416 VPWR VGND sg13g2_decap_8
XFILLER_32_221 VPWR VGND sg13g2_decap_8
XFILLER_32_298 VPWR VGND sg13g2_decap_8
X_0964_ net98 VGND VPWR _0124_ daisychain\[60\] clknet_5_26__leaf_clk sg13g2_dfrbpq_1
X_0895_ VPWR _0247_ daisychain\[54\] VGND sg13g2_inv_1
XFILLER_9_494 VPWR VGND sg13g2_decap_8
XFILLER_4_81 VPWR VGND sg13g2_decap_8
XFILLER_23_232 VPWR VGND sg13g2_decap_8
XFILLER_24_700 VPWR VGND sg13g2_decap_8
XFILLER_36_560 VPWR VGND sg13g2_decap_8
XFILLER_11_438 VPWR VGND sg13g2_decap_8
XFILLER_23_57 VPWR VGND sg13g2_decap_8
XFILLER_2_158 VPWR VGND sg13g2_decap_8
XFILLER_3_615 VPWR VGND sg13g2_fill_2
XFILLER_48_21 VPWR VGND sg13g2_decap_8
XFILLER_0_28 VPWR VGND sg13g2_decap_8
XFILLER_46_357 VPWR VGND sg13g2_decap_8
XFILLER_48_98 VPWR VGND sg13g2_decap_8
XFILLER_14_254 VPWR VGND sg13g2_decap_8
XFILLER_42_574 VPWR VGND sg13g2_decap_8
XFILLER_42_585 VPWR VGND sg13g2_fill_1
Xfanout91 net92 net91 VPWR VGND sg13g2_buf_1
Xfanout80 net81 net80 VPWR VGND sg13g2_buf_1
XFILLER_10_482 VPWR VGND sg13g2_decap_8
X_0680_ _0247_ net68 _0420_ _0421_ VPWR VGND sg13g2_a21o_1
XFILLER_6_442 VPWR VGND sg13g2_decap_8
XFILLER_29_4 VPWR VGND sg13g2_decap_4
XFILLER_49_151 VPWR VGND sg13g2_decap_8
XFILLER_18_560 VPWR VGND sg13g2_decap_8
XFILLER_37_357 VPWR VGND sg13g2_decap_8
XFILLER_20_213 VPWR VGND sg13g2_decap_8
XFILLER_33_585 VPWR VGND sg13g2_decap_8
X_0947_ net112 VGND VPWR _0107_ daisychain\[43\] clknet_5_17__leaf_clk sg13g2_dfrbpq_1
XFILLER_9_291 VPWR VGND sg13g2_decap_8
X_0878_ VPWR _0005_ state\[46\] VGND sg13g2_inv_1
XFILLER_18_35 VPWR VGND sg13g2_decap_8
XFILLER_28_368 VPWR VGND sg13g2_decap_8
XFILLER_11_235 VPWR VGND sg13g2_decap_8
XFILLER_24_574 VPWR VGND sg13g2_decap_8
XFILLER_34_56 VPWR VGND sg13g2_decap_8
XFILLER_43_327 VPWR VGND sg13g2_decap_8
XFILLER_3_445 VPWR VGND sg13g2_decap_8
XFILLER_7_217 VPWR VGND sg13g2_decap_8
Xclkbuf_5_29__f_clk clknet_5_29__leaf_clk clknet_4_14_0_clk VPWR VGND sg13g2_buf_16
XFILLER_15_541 VPWR VGND sg13g2_decap_8
XFILLER_19_368 VPWR VGND sg13g2_decap_8
XFILLER_46_154 VPWR VGND sg13g2_decap_8
XFILLER_30_522 VPWR VGND sg13g2_decap_8
XFILLER_30_599 VPWR VGND sg13g2_decap_8
XFILLER_42_371 VPWR VGND sg13g2_decap_8
X_0801_ VPWR _0200_ daisychain\[7\] VGND sg13g2_inv_1
X_0732_ _0295_ VPWR _0140_ VGND net82 _0035_ sg13g2_o21ai_1
X_0663_ net93 VPWR _0408_ VGND net72 state\[50\] sg13g2_o21ai_1
X_0594_ _0096_ _0355_ _0356_ net51 _0225_ VPWR VGND sg13g2_a22oi_1
XFILLER_37_154 VPWR VGND sg13g2_decap_8
XFILLER_21_533 VPWR VGND sg13g2_decap_8
XFILLER_25_338 VPWR VGND sg13g2_decap_8
XFILLER_33_382 VPWR VGND sg13g2_decap_8
XFILLER_0_448 VPWR VGND sg13g2_decap_8
XFILLER_29_34 VPWR VGND sg13g2_decap_8
XFILLER_29_622 VPWR VGND sg13g2_decap_8
XFILLER_16_305 VPWR VGND sg13g2_decap_8
XFILLER_28_165 VPWR VGND sg13g2_decap_8
XFILLER_29_699 VPWR VGND sg13g2_decap_8
XFILLER_43_102 VPWR VGND sg13g2_decap_8
XFILLER_45_77 VPWR VGND sg13g2_decap_8
Xdigitalen.g\[2\].u.inv2 VPWR digitalen.g\[2\].u.OUTP digitalen.g\[2\].u.OUTN VGND
+ sg13g2_inv_1
XFILLER_12_566 VPWR VGND sg13g2_decap_8
XFILLER_24_371 VPWR VGND sg13g2_decap_8
XFILLER_43_179 VPWR VGND sg13g2_decap_4
XFILLER_8_559 VPWR VGND sg13g2_decap_8
XFILLER_3_242 VPWR VGND sg13g2_decap_8
XFILLER_19_165 VPWR VGND sg13g2_decap_8
XFILLER_39_419 VPWR VGND sg13g2_decap_8
XFILLER_47_441 VPWR VGND sg13g2_decap_8
X_1000_ net113 VGND VPWR _0160_ state\[32\] clknet_5_20__leaf_clk sg13g2_dfrbpq_1
XFILLER_22_308 VPWR VGND sg13g2_decap_8
XFILLER_34_168 VPWR VGND sg13g2_decap_8
XFILLER_30_396 VPWR VGND sg13g2_decap_8
X_0715_ _0126_ _0446_ _0447_ net34 _0255_ VPWR VGND sg13g2_a22oi_1
Xclkbuf_5_12__f_clk clknet_5_12__leaf_clk clknet_4_6_0_clk VPWR VGND sg13g2_buf_16
X_0646_ _0109_ _0394_ _0395_ net50 _0238_ VPWR VGND sg13g2_a22oi_1
X_0577_ VGND VPWR net24 daisychain\[27\] _0344_ net39 sg13g2_a21oi_1
XFILLER_25_135 VPWR VGND sg13g2_decap_8
XFILLER_26_658 VPWR VGND sg13g2_decap_8
XFILLER_38_441 VPWR VGND sg13g2_decap_8
XFILLER_15_58 VPWR VGND sg13g2_decap_8
XFILLER_21_330 VPWR VGND sg13g2_decap_8
XFILLER_22_820 VPWR VGND sg13g2_fill_2
XFILLER_40_127 VPWR VGND sg13g2_decap_8
XFILLER_31_79 VPWR VGND sg13g2_decap_8
Xoutput13 net13 uio_out[6] VPWR VGND sg13g2_buf_1
XFILLER_5_529 VPWR VGND sg13g2_decap_8
XFILLER_0_245 VPWR VGND sg13g2_decap_8
XFILLER_17_603 VPWR VGND sg13g2_decap_8
XFILLER_48_238 VPWR VGND sg13g2_decap_8
XFILLER_16_102 VPWR VGND sg13g2_decap_8
XFILLER_16_179 VPWR VGND sg13g2_decap_8
XFILLER_25_691 VPWR VGND sg13g2_decap_8
XFILLER_29_496 VPWR VGND sg13g2_decap_8
XFILLER_31_149 VPWR VGND sg13g2_decap_8
XFILLER_32_606 VPWR VGND sg13g2_decap_8
XFILLER_44_422 VPWR VGND sg13g2_decap_8
XFILLER_12_363 VPWR VGND sg13g2_decap_8
XFILLER_8_356 VPWR VGND sg13g2_decap_8
X_0500_ _0202_ net61 _0285_ _0286_ VPWR VGND sg13g2_a21o_1
XFILLER_11_4 VPWR VGND sg13g2_decap_8
XFILLER_35_455 VPWR VGND sg13g2_decap_8
XFILLER_22_105 VPWR VGND sg13g2_decap_8
XFILLER_23_617 VPWR VGND sg13g2_decap_8
XFILLER_30_193 VPWR VGND sg13g2_decap_8
XFILLER_7_70 VPWR VGND sg13g2_decap_8
X_0629_ VGND VPWR net28 daisychain\[40\] _0383_ net51 sg13g2_a21oi_1
XFILLER_13_149 VPWR VGND sg13g2_decap_8
XFILLER_26_35 VPWR VGND sg13g2_decap_8
XFILLER_26_455 VPWR VGND sg13g2_decap_8
XFILLER_41_447 VPWR VGND sg13g2_decap_8
XFILLER_22_672 VPWR VGND sg13g2_decap_8
XFILLER_9_109 VPWR VGND sg13g2_decap_8
XFILLER_5_326 VPWR VGND sg13g2_decap_8
XFILLER_1_532 VPWR VGND sg13g2_decap_8
XFILLER_1_587 VPWR VGND sg13g2_fill_1
XFILLER_3_39 VPWR VGND sg13g2_decap_8
XFILLER_17_400 VPWR VGND sg13g2_decap_8
XFILLER_29_293 VPWR VGND sg13g2_decap_8
XFILLER_49_536 VPWR VGND sg13g2_decap_8
XFILLER_12_160 VPWR VGND sg13g2_decap_8
XFILLER_17_477 VPWR VGND sg13g2_decap_8
XFILLER_32_403 VPWR VGND sg13g2_decap_8
XFILLER_44_296 VPWR VGND sg13g2_decap_8
X_0980_ net104 VGND VPWR _0140_ state\[12\] clknet_5_5__leaf_clk sg13g2_dfrbpq_1
XFILLER_9_621 VPWR VGND sg13g2_decap_8
XFILLER_40_491 VPWR VGND sg13g2_decap_8
XFILLER_9_676 VPWR VGND sg13g2_decap_4
XFILLER_8_153 VPWR VGND sg13g2_decap_8
XFILLER_23_414 VPWR VGND sg13g2_decap_8
XFILLER_35_252 VPWR VGND sg13g2_decap_8
XFILLER_12_48 VPWR VGND sg13g2_decap_8
XFILLER_27_720 VPWR VGND sg13g2_decap_8
XFILLER_37_56 VPWR VGND sg13g2_decap_8
XFILLER_46_539 VPWR VGND sg13g2_decap_8
XFILLER_14_436 VPWR VGND sg13g2_decap_8
XFILLER_26_252 VPWR VGND sg13g2_decap_8
XFILLER_41_244 VPWR VGND sg13g2_decap_8
XFILLER_10_664 VPWR VGND sg13g2_decap_4
XFILLER_5_123 VPWR VGND sg13g2_decap_8
XFILLER_49_333 VPWR VGND sg13g2_decap_8
XFILLER_17_274 VPWR VGND sg13g2_decap_8
XFILLER_32_200 VPWR VGND sg13g2_decap_8
XFILLER_33_723 VPWR VGND sg13g2_decap_8
XFILLER_37_539 VPWR VGND sg13g2_decap_8
XFILLER_32_277 VPWR VGND sg13g2_decap_8
XFILLER_33_778 VPWR VGND sg13g2_decap_4
X_0894_ VPWR _0014_ state\[54\] VGND sg13g2_inv_1
X_0963_ net97 VGND VPWR _0123_ daisychain\[59\] clknet_5_27__leaf_clk sg13g2_dfrbpq_1
XFILLER_9_473 VPWR VGND sg13g2_decap_8
XFILLER_4_60 VPWR VGND sg13g2_decap_8
XFILLER_11_417 VPWR VGND sg13g2_decap_8
XFILLER_23_211 VPWR VGND sg13g2_decap_8
XFILLER_23_288 VPWR VGND sg13g2_decap_8
XFILLER_23_36 VPWR VGND sg13g2_decap_8
XFILLER_24_712 VPWR VGND sg13g2_fill_2
XFILLER_2_137 VPWR VGND sg13g2_decap_8
XFILLER_15_745 VPWR VGND sg13g2_decap_8
XFILLER_27_594 VPWR VGND sg13g2_decap_8
XFILLER_46_336 VPWR VGND sg13g2_decap_8
XFILLER_48_77 VPWR VGND sg13g2_decap_8
XFILLER_10_461 VPWR VGND sg13g2_decap_8
XFILLER_14_233 VPWR VGND sg13g2_decap_8
XFILLER_42_553 VPWR VGND sg13g2_decap_8
Xfanout92 net95 net92 VPWR VGND sg13g2_buf_1
Xfanout81 net87 net81 VPWR VGND sg13g2_buf_1
Xfanout70 net71 net70 VPWR VGND sg13g2_buf_1
XFILLER_43_7 VPWR VGND sg13g2_decap_8
XFILLER_6_498 VPWR VGND sg13g2_decap_8
XFILLER_6_421 VPWR VGND sg13g2_decap_8
XFILLER_37_336 VPWR VGND sg13g2_decap_8
XFILLER_49_130 VPWR VGND sg13g2_decap_8
XFILLER_25_509 VPWR VGND sg13g2_decap_8
XFILLER_33_564 VPWR VGND sg13g2_decap_8
XFILLER_20_269 VPWR VGND sg13g2_decap_8
X_0877_ VPWR _0238_ daisychain\[45\] VGND sg13g2_inv_1
X_0946_ net113 VGND VPWR _0106_ daisychain\[42\] clknet_5_18__leaf_clk sg13g2_dfrbpq_1
XFILLER_9_270 VPWR VGND sg13g2_decap_8
XFILLER_0_619 VPWR VGND sg13g2_fill_2
XFILLER_28_347 VPWR VGND sg13g2_decap_8
XFILLER_43_306 VPWR VGND sg13g2_decap_8
XFILLER_11_214 VPWR VGND sg13g2_decap_8
XFILLER_24_553 VPWR VGND sg13g2_decap_8
XFILLER_34_35 VPWR VGND sg13g2_decap_8
XFILLER_3_424 VPWR VGND sg13g2_decap_8
XFILLER_19_347 VPWR VGND sg13g2_decap_8
XFILLER_46_133 VPWR VGND sg13g2_decap_8
XFILLER_47_623 VPWR VGND sg13g2_decap_8
XFILLER_47_634 VPWR VGND sg13g2_decap_8
XFILLER_15_520 VPWR VGND sg13g2_decap_8
XFILLER_15_586 VPWR VGND sg13g2_decap_8
XFILLER_27_391 VPWR VGND sg13g2_decap_8
XFILLER_30_501 VPWR VGND sg13g2_decap_8
XFILLER_42_350 VPWR VGND sg13g2_decap_8
XFILLER_47_689 VPWR VGND sg13g2_fill_2
XFILLER_30_578 VPWR VGND sg13g2_decap_8
X_0800_ VPWR _0061_ state\[7\] VGND sg13g2_inv_1
X_0731_ _0292_ VPWR _0139_ VGND net81 _0034_ sg13g2_o21ai_1
XFILLER_41_4 VPWR VGND sg13g2_fill_1
X_0662_ _0113_ _0406_ _0407_ net53 _0242_ VPWR VGND sg13g2_a22oi_1
X_0593_ VGND VPWR net25 daisychain\[31\] _0356_ net44 sg13g2_a21oi_1
XFILLER_6_295 VPWR VGND sg13g2_decap_8
XFILLER_25_317 VPWR VGND sg13g2_decap_8
XFILLER_37_133 VPWR VGND sg13g2_decap_8
XFILLER_38_689 VPWR VGND sg13g2_fill_2
XFILLER_21_512 VPWR VGND sg13g2_decap_8
XFILLER_21_589 VPWR VGND sg13g2_decap_8
XFILLER_33_361 VPWR VGND sg13g2_decap_8
XFILLER_40_309 VPWR VGND sg13g2_decap_8
XFILLER_20_59 VPWR VGND sg13g2_decap_8
X_0929_ net101 VGND VPWR _0089_ daisychain\[25\] clknet_5_6__leaf_clk sg13g2_dfrbpq_1
XFILLER_0_427 VPWR VGND sg13g2_decap_8
XFILLER_29_13 VPWR VGND sg13g2_decap_8
XFILLER_29_601 VPWR VGND sg13g2_decap_8
XFILLER_24_350 VPWR VGND sg13g2_decap_8
XFILLER_28_144 VPWR VGND sg13g2_decap_8
XFILLER_29_678 VPWR VGND sg13g2_decap_8
XFILLER_43_158 VPWR VGND sg13g2_decap_8
XFILLER_45_56 VPWR VGND sg13g2_decap_8
XFILLER_12_545 VPWR VGND sg13g2_decap_8
XFILLER_8_538 VPWR VGND sg13g2_decap_8
XFILLER_4_700 VPWR VGND sg13g2_fill_2
XFILLER_3_221 VPWR VGND sg13g2_decap_8
XFILLER_3_298 VPWR VGND sg13g2_decap_8
XFILLER_19_144 VPWR VGND sg13g2_decap_8
XFILLER_35_637 VPWR VGND sg13g2_decap_8
XFILLER_47_420 VPWR VGND sg13g2_decap_8
XFILLER_47_497 VPWR VGND sg13g2_decap_8
XFILLER_15_394 VPWR VGND sg13g2_decap_8
XFILLER_34_147 VPWR VGND sg13g2_decap_8
XFILLER_30_375 VPWR VGND sg13g2_decap_8
X_0714_ VGND VPWR net33 daisychain\[61\] _0447_ net34 sg13g2_a21oi_1
X_0645_ VGND VPWR net28 daisychain\[44\] _0395_ net50 sg13g2_a21oi_1
XFILLER_38_420 VPWR VGND sg13g2_decap_8
X_0576_ _0221_ net60 _0342_ _0343_ VPWR VGND sg13g2_a21o_1
XFILLER_15_37 VPWR VGND sg13g2_decap_8
XFILLER_25_114 VPWR VGND sg13g2_decap_8
XFILLER_26_637 VPWR VGND sg13g2_decap_8
XFILLER_38_497 VPWR VGND sg13g2_decap_8
XFILLER_40_106 VPWR VGND sg13g2_decap_8
XFILLER_21_386 VPWR VGND sg13g2_decap_8
XFILLER_31_58 VPWR VGND sg13g2_decap_8
XFILLER_5_508 VPWR VGND sg13g2_decap_8
XFILLER_0_224 VPWR VGND sg13g2_decap_8
Xoutput14 net14 uio_out[7] VPWR VGND sg13g2_buf_1
XFILLER_29_475 VPWR VGND sg13g2_decap_8
XFILLER_44_401 VPWR VGND sg13g2_decap_8
XFILLER_48_217 VPWR VGND sg13g2_decap_8
XFILLER_12_342 VPWR VGND sg13g2_decap_8
XFILLER_16_158 VPWR VGND sg13g2_decap_8
XFILLER_17_659 VPWR VGND sg13g2_fill_2
XFILLER_25_670 VPWR VGND sg13g2_decap_8
XFILLER_31_128 VPWR VGND sg13g2_decap_8
XFILLER_8_335 VPWR VGND sg13g2_decap_8
XFILLER_35_434 VPWR VGND sg13g2_decap_8
XFILLER_47_294 VPWR VGND sg13g2_decap_8
XFILLER_15_191 VPWR VGND sg13g2_decap_8
XFILLER_30_172 VPWR VGND sg13g2_decap_8
X_0628_ _0234_ net71 _0381_ _0382_ VPWR VGND sg13g2_a21o_1
X_0559_ net82 VPWR _0330_ VGND net62 state\[24\] sg13g2_o21ai_1
XFILLER_13_128 VPWR VGND sg13g2_decap_8
XFILLER_22_651 VPWR VGND sg13g2_decap_8
XFILLER_26_434 VPWR VGND sg13g2_decap_8
XFILLER_38_294 VPWR VGND sg13g2_decap_8
XFILLER_41_426 VPWR VGND sg13g2_decap_8
XFILLER_21_183 VPWR VGND sg13g2_decap_8
XFILLER_42_79 VPWR VGND sg13g2_decap_8
XFILLER_5_305 VPWR VGND sg13g2_decap_8
XFILLER_1_511 VPWR VGND sg13g2_decap_8
XFILLER_3_18 VPWR VGND sg13g2_decap_8
XFILLER_49_515 VPWR VGND sg13g2_decap_8
XFILLER_17_456 VPWR VGND sg13g2_decap_8
XFILLER_29_272 VPWR VGND sg13g2_decap_8
XFILLER_13_684 VPWR VGND sg13g2_fill_1
XFILLER_32_459 VPWR VGND sg13g2_decap_8
XFILLER_40_470 VPWR VGND sg13g2_decap_8
XFILLER_44_275 VPWR VGND sg13g2_decap_8
XFILLER_8_132 VPWR VGND sg13g2_decap_8
XFILLER_4_382 VPWR VGND sg13g2_decap_8
XFILLER_27_209 VPWR VGND sg13g2_decap_8
XFILLER_48_581 VPWR VGND sg13g2_decap_8
XFILLER_35_231 VPWR VGND sg13g2_decap_8
XFILLER_36_798 VPWR VGND sg13g2_decap_8
XFILLER_12_27 VPWR VGND sg13g2_decap_8
XFILLER_31_492 VPWR VGND sg13g2_decap_8
XFILLER_2_319 VPWR VGND sg13g2_decap_8
XFILLER_26_231 VPWR VGND sg13g2_decap_8
XFILLER_37_35 VPWR VGND sg13g2_decap_8
XFILLER_46_518 VPWR VGND sg13g2_decap_8
XFILLER_10_610 VPWR VGND sg13g2_decap_4
XFILLER_10_654 VPWR VGND sg13g2_fill_1
XFILLER_14_415 VPWR VGND sg13g2_decap_8
XFILLER_41_223 VPWR VGND sg13g2_decap_8
XFILLER_5_179 VPWR VGND sg13g2_decap_8
XFILLER_5_102 VPWR VGND sg13g2_decap_8
XFILLER_1_385 VPWR VGND sg13g2_decap_8
XFILLER_37_518 VPWR VGND sg13g2_decap_8
XFILLER_49_389 VPWR VGND sg13g2_decap_8
XFILLER_49_312 VPWR VGND sg13g2_decap_8
XFILLER_17_253 VPWR VGND sg13g2_decap_8
XFILLER_27_90 VPWR VGND sg13g2_decap_8
XFILLER_32_256 VPWR VGND sg13g2_decap_8
XFILLER_45_595 VPWR VGND sg13g2_decap_4
XFILLER_13_492 VPWR VGND sg13g2_decap_8
X_0893_ VPWR _0246_ daisychain\[53\] VGND sg13g2_inv_1
X_0962_ net97 VGND VPWR _0122_ daisychain\[58\] clknet_5_27__leaf_clk sg13g2_dfrbpq_1
XFILLER_9_452 VPWR VGND sg13g2_decap_8
XFILLER_28_529 VPWR VGND sg13g2_decap_8
XFILLER_23_267 VPWR VGND sg13g2_decap_8
XFILLER_36_595 VPWR VGND sg13g2_decap_8
XFILLER_2_116 VPWR VGND sg13g2_decap_8
XFILLER_19_529 VPWR VGND sg13g2_decap_8
XFILLER_46_315 VPWR VGND sg13g2_decap_8
XFILLER_48_56 VPWR VGND sg13g2_decap_8
XFILLER_14_212 VPWR VGND sg13g2_decap_8
XFILLER_27_573 VPWR VGND sg13g2_decap_8
XFILLER_42_532 VPWR VGND sg13g2_decap_8
XFILLER_10_440 VPWR VGND sg13g2_decap_8
XFILLER_14_289 VPWR VGND sg13g2_decap_8
Xfanout93 net94 net93 VPWR VGND sg13g2_buf_1
Xfanout82 net83 net82 VPWR VGND sg13g2_buf_1
Xfanout71 net74 net71 VPWR VGND sg13g2_buf_1
Xfanout60 net66 net60 VPWR VGND sg13g2_buf_1
XFILLER_9_39 VPWR VGND sg13g2_decap_8
XFILLER_6_400 VPWR VGND sg13g2_decap_8
XFILLER_2_672 VPWR VGND sg13g2_decap_4
XFILLER_36_7 VPWR VGND sg13g2_decap_8
XFILLER_6_477 VPWR VGND sg13g2_decap_8
XFILLER_1_182 VPWR VGND sg13g2_decap_8
XFILLER_37_315 VPWR VGND sg13g2_decap_8
XFILLER_49_186 VPWR VGND sg13g2_decap_8
XFILLER_18_595 VPWR VGND sg13g2_decap_8
XFILLER_20_248 VPWR VGND sg13g2_decap_8
XFILLER_33_543 VPWR VGND sg13g2_decap_8
XFILLER_45_392 VPWR VGND sg13g2_decap_8
X_0876_ VPWR _0004_ state\[45\] VGND sg13g2_inv_1
X_0945_ net113 VGND VPWR _0105_ daisychain\[41\] clknet_5_17__leaf_clk sg13g2_dfrbpq_1
XFILLER_24_532 VPWR VGND sg13g2_decap_8
XFILLER_28_326 VPWR VGND sg13g2_decap_8
XFILLER_34_14 VPWR VGND sg13g2_decap_8
XFILLER_36_392 VPWR VGND sg13g2_decap_8
XFILLER_3_403 VPWR VGND sg13g2_decap_8
XFILLER_19_326 VPWR VGND sg13g2_decap_8
XFILLER_46_112 VPWR VGND sg13g2_decap_8
XFILLER_47_602 VPWR VGND sg13g2_decap_8
XFILLER_27_370 VPWR VGND sg13g2_decap_8
XFILLER_34_329 VPWR VGND sg13g2_decap_8
XFILLER_46_189 VPWR VGND sg13g2_decap_8
XFILLER_24_91 VPWR VGND sg13g2_decap_8
XFILLER_30_557 VPWR VGND sg13g2_decap_8
X_0730_ _0289_ VPWR _0138_ VGND net82 _0033_ sg13g2_o21ai_1
X_0661_ VGND VPWR net29 daisychain\[48\] _0407_ net53 sg13g2_a21oi_1
XFILLER_6_274 VPWR VGND sg13g2_decap_8
XFILLER_2_480 VPWR VGND sg13g2_decap_8
XFILLER_38_602 VPWR VGND sg13g2_decap_8
X_0592_ _0225_ net71 _0354_ _0355_ VPWR VGND sg13g2_a21o_1
XFILLER_18_392 VPWR VGND sg13g2_decap_8
XFILLER_1_84 VPWR VGND sg13g2_decap_8
XFILLER_37_112 VPWR VGND sg13g2_decap_8
XFILLER_37_189 VPWR VGND sg13g2_decap_8
XFILLER_38_679 VPWR VGND sg13g2_fill_2
XFILLER_21_568 VPWR VGND sg13g2_decap_8
XFILLER_33_340 VPWR VGND sg13g2_decap_8
XFILLER_0_406 VPWR VGND sg13g2_decap_8
XFILLER_20_38 VPWR VGND sg13g2_decap_8
X_0859_ VPWR _0229_ daisychain\[36\] VGND sg13g2_inv_1
X_0928_ net103 VGND VPWR _0088_ daisychain\[24\] clknet_5_8__leaf_clk sg13g2_dfrbpq_1
XFILLER_28_123 VPWR VGND sg13g2_decap_8
XFILLER_29_657 VPWR VGND sg13g2_decap_8
XFILLER_29_69 VPWR VGND sg13g2_decap_8
XFILLER_12_524 VPWR VGND sg13g2_decap_8
XFILLER_43_137 VPWR VGND sg13g2_decap_8
XFILLER_45_35 VPWR VGND sg13g2_decap_8
XFILLER_3_200 VPWR VGND sg13g2_decap_8
XFILLER_8_517 VPWR VGND sg13g2_decap_8
XFILLER_6_29 VPWR VGND sg13g2_decap_8
XFILLER_6_18 VPWR VGND sg13g2_decap_8
XFILLER_4_712 VPWR VGND sg13g2_fill_2
XFILLER_3_277 VPWR VGND sg13g2_decap_8
XFILLER_19_123 VPWR VGND sg13g2_decap_8
XFILLER_28_690 VPWR VGND sg13g2_decap_8
XFILLER_34_126 VPWR VGND sg13g2_decap_8
XFILLER_35_616 VPWR VGND sg13g2_decap_8
XFILLER_47_476 VPWR VGND sg13g2_decap_8
XFILLER_15_373 VPWR VGND sg13g2_decap_8
XFILLER_30_354 VPWR VGND sg13g2_decap_8
XFILLER_31_811 VPWR VGND sg13g2_decap_4
XFILLER_42_170 VPWR VGND sg13g2_decap_4
X_0713_ VGND VPWR _0446_ _0445_ _0444_ sg13g2_or2_1
X_0644_ _0238_ net70 _0393_ _0394_ VPWR VGND sg13g2_a21o_1
X_0575_ net81 VPWR _0342_ VGND net60 state\[28\] sg13g2_o21ai_1
XFILLER_22_822 VPWR VGND sg13g2_fill_1
XFILLER_26_616 VPWR VGND sg13g2_decap_8
XFILLER_38_476 VPWR VGND sg13g2_decap_8
XFILLER_21_365 VPWR VGND sg13g2_decap_8
XFILLER_31_37 VPWR VGND sg13g2_decap_8
XFILLER_0_203 VPWR VGND sg13g2_decap_8
Xoutput15 net15 uo_out[0] VPWR VGND sg13g2_buf_1
XFILLER_49_719 VPWR VGND sg13g2_fill_1
XFILLER_16_137 VPWR VGND sg13g2_decap_8
XFILLER_17_638 VPWR VGND sg13g2_decap_8
XFILLER_29_454 VPWR VGND sg13g2_decap_8
XFILLER_44_457 VPWR VGND sg13g2_decap_8
XFILLER_12_321 VPWR VGND sg13g2_decap_8
XFILLER_31_107 VPWR VGND sg13g2_decap_8
XFILLER_44_479 VPWR VGND sg13g2_decap_8
XFILLER_8_314 VPWR VGND sg13g2_decap_8
XFILLER_12_398 VPWR VGND sg13g2_decap_8
XFILLER_21_92 VPWR VGND sg13g2_decap_8
XFILLER_4_575 VPWR VGND sg13g2_fill_2
XFILLER_0_792 VPWR VGND sg13g2_fill_2
XFILLER_39_229 VPWR VGND sg13g2_decap_8
XFILLER_15_170 VPWR VGND sg13g2_decap_8
XFILLER_35_413 VPWR VGND sg13g2_decap_8
XFILLER_47_273 VPWR VGND sg13g2_decap_8
XFILLER_30_151 VPWR VGND sg13g2_decap_8
XFILLER_31_674 VPWR VGND sg13g2_decap_8
XFILLER_43_490 VPWR VGND sg13g2_decap_8
X_0627_ net92 VPWR _0381_ VGND net71 state\[41\] sg13g2_o21ai_1
X_0558_ _0087_ _0328_ _0329_ net41 _0216_ VPWR VGND sg13g2_a22oi_1
XFILLER_26_413 VPWR VGND sg13g2_decap_8
XFILLER_38_273 VPWR VGND sg13g2_decap_8
X_0489_ VGND VPWR net23 daisychain\[5\] _0278_ net38 sg13g2_a21oi_1
XFILLER_13_107 VPWR VGND sg13g2_decap_8
XFILLER_21_162 VPWR VGND sg13g2_decap_8
XFILLER_22_630 VPWR VGND sg13g2_decap_8
XFILLER_34_490 VPWR VGND sg13g2_decap_8
XFILLER_41_405 VPWR VGND sg13g2_decap_8
XFILLER_1_567 VPWR VGND sg13g2_decap_4
XFILLER_1_578 VPWR VGND sg13g2_decap_8
XFILLER_17_435 VPWR VGND sg13g2_decap_8
XFILLER_29_251 VPWR VGND sg13g2_decap_8
XFILLER_32_438 VPWR VGND sg13g2_decap_8
XFILLER_44_254 VPWR VGND sg13g2_decap_8
XFILLER_12_195 VPWR VGND sg13g2_decap_8
XFILLER_16_81 VPWR VGND sg13g2_decap_8
XFILLER_9_656 VPWR VGND sg13g2_fill_2
XFILLER_8_188 VPWR VGND sg13g2_decap_8
XFILLER_8_111 VPWR VGND sg13g2_decap_8
XFILLER_4_361 VPWR VGND sg13g2_decap_8
XFILLER_35_210 VPWR VGND sg13g2_decap_8
XFILLER_48_560 VPWR VGND sg13g2_decap_8
XFILLER_23_449 VPWR VGND sg13g2_decap_8
XFILLER_31_471 VPWR VGND sg13g2_decap_8
XFILLER_35_287 VPWR VGND sg13g2_decap_8
XFILLER_37_14 VPWR VGND sg13g2_decap_8
XFILLER_26_210 VPWR VGND sg13g2_decap_8
XFILLER_26_287 VPWR VGND sg13g2_decap_8
XFILLER_41_202 VPWR VGND sg13g2_decap_8
XFILLER_42_725 VPWR VGND sg13g2_decap_8
XFILLER_42_736 VPWR VGND sg13g2_fill_2
XFILLER_41_279 VPWR VGND sg13g2_decap_8
XFILLER_5_158 VPWR VGND sg13g2_decap_8
XFILLER_18_722 VPWR VGND sg13g2_decap_8
XFILLER_1_364 VPWR VGND sg13g2_decap_8
XFILLER_49_368 VPWR VGND sg13g2_decap_8
XFILLER_17_232 VPWR VGND sg13g2_decap_8
XFILLER_18_766 VPWR VGND sg13g2_decap_8
XFILLER_32_235 VPWR VGND sg13g2_decap_8
XFILLER_45_574 VPWR VGND sg13g2_decap_8
X_0961_ net97 VGND VPWR _0121_ daisychain\[57\] clknet_5_26__leaf_clk sg13g2_dfrbpq_1
XFILLER_13_471 VPWR VGND sg13g2_decap_8
X_0892_ VPWR _0013_ state\[53\] VGND sg13g2_inv_1
XFILLER_9_431 VPWR VGND sg13g2_decap_8
XFILLER_4_95 VPWR VGND sg13g2_decap_8
XFILLER_24_714 VPWR VGND sg13g2_fill_1
XFILLER_28_508 VPWR VGND sg13g2_decap_8
XFILLER_36_574 VPWR VGND sg13g2_decap_8
XFILLER_23_246 VPWR VGND sg13g2_decap_8
Xclkbuf_5_18__f_clk clknet_5_18__leaf_clk clknet_4_9_0_clk VPWR VGND sg13g2_buf_16
XFILLER_19_508 VPWR VGND sg13g2_decap_8
XFILLER_48_35 VPWR VGND sg13g2_decap_8
XFILLER_14_268 VPWR VGND sg13g2_decap_8
XFILLER_27_552 VPWR VGND sg13g2_decap_8
XFILLER_30_717 VPWR VGND sg13g2_decap_8
XFILLER_42_511 VPWR VGND sg13g2_decap_8
XFILLER_9_18 VPWR VGND sg13g2_decap_8
XFILLER_10_496 VPWR VGND sg13g2_decap_8
XFILLER_13_93 VPWR VGND sg13g2_decap_8
Xfanout94 net95 net94 VPWR VGND sg13g2_buf_1
Xfanout83 net87 net83 VPWR VGND sg13g2_buf_1
Xfanout72 net73 net72 VPWR VGND sg13g2_buf_1
Xfanout61 net62 net61 VPWR VGND sg13g2_buf_1
Xfanout50 net51 net50 VPWR VGND sg13g2_buf_1
XFILLER_6_456 VPWR VGND sg13g2_decap_8
XFILLER_1_161 VPWR VGND sg13g2_decap_8
XFILLER_18_574 VPWR VGND sg13g2_decap_8
XFILLER_33_522 VPWR VGND sg13g2_decap_8
XFILLER_45_371 VPWR VGND sg13g2_decap_8
XFILLER_49_165 VPWR VGND sg13g2_decap_8
XFILLER_20_227 VPWR VGND sg13g2_decap_8
XFILLER_33_599 VPWR VGND sg13g2_decap_8
X_0944_ net113 VGND VPWR _0104_ daisychain\[40\] clknet_5_20__leaf_clk sg13g2_dfrbpq_1
X_0875_ VPWR _0237_ daisychain\[44\] VGND sg13g2_inv_1
XFILLER_18_49 VPWR VGND sg13g2_decap_8
XFILLER_28_305 VPWR VGND sg13g2_decap_8
XFILLER_29_817 VPWR VGND sg13g2_decap_4
XFILLER_24_511 VPWR VGND sg13g2_decap_8
XFILLER_24_588 VPWR VGND sg13g2_decap_8
XFILLER_36_371 VPWR VGND sg13g2_decap_8
XFILLER_11_249 VPWR VGND sg13g2_decap_8
XFILLER_3_459 VPWR VGND sg13g2_decap_8
XFILLER_19_305 VPWR VGND sg13g2_decap_8
XFILLER_34_308 VPWR VGND sg13g2_decap_8
XFILLER_46_168 VPWR VGND sg13g2_decap_8
XFILLER_15_555 VPWR VGND sg13g2_decap_4
XFILLER_24_70 VPWR VGND sg13g2_decap_8
XFILLER_30_536 VPWR VGND sg13g2_decap_8
XFILLER_42_385 VPWR VGND sg13g2_decap_8
XFILLER_10_293 VPWR VGND sg13g2_decap_8
X_0660_ _0242_ net72 _0405_ _0406_ VPWR VGND sg13g2_a21o_1
X_0591_ net92 VPWR _0354_ VGND net71 state\[32\] sg13g2_o21ai_1
XFILLER_6_253 VPWR VGND sg13g2_decap_8
XFILLER_18_371 VPWR VGND sg13g2_decap_8
XFILLER_1_63 VPWR VGND sg13g2_decap_8
XFILLER_37_168 VPWR VGND sg13g2_decap_8
XFILLER_46_691 VPWR VGND sg13g2_decap_4
XFILLER_21_547 VPWR VGND sg13g2_decap_8
XFILLER_33_396 VPWR VGND sg13g2_decap_8
X_0927_ net107 VGND VPWR _0087_ daisychain\[23\] clknet_5_9__leaf_clk sg13g2_dfrbpq_1
X_0858_ VPWR _0026_ state\[36\] VGND sg13g2_inv_1
X_0789_ VPWR _0194_ daisychain\[1\] VGND sg13g2_inv_1
XFILLER_16_319 VPWR VGND sg13g2_decap_8
XFILLER_17_809 VPWR VGND sg13g2_decap_8
XFILLER_28_102 VPWR VGND sg13g2_decap_8
XFILLER_28_179 VPWR VGND sg13g2_decap_8
XFILLER_29_48 VPWR VGND sg13g2_decap_8
XFILLER_29_636 VPWR VGND sg13g2_decap_8
XFILLER_43_116 VPWR VGND sg13g2_decap_8
XFILLER_45_14 VPWR VGND sg13g2_decap_8
XFILLER_12_503 VPWR VGND sg13g2_decap_8
XFILLER_24_385 VPWR VGND sg13g2_decap_8
XFILLER_20_591 VPWR VGND sg13g2_decap_8
XFILLER_10_83 VPWR VGND sg13g2_decap_8
XFILLER_19_102 VPWR VGND sg13g2_decap_8
XFILLER_3_256 VPWR VGND sg13g2_decap_8
XFILLER_15_352 VPWR VGND sg13g2_decap_8
XFILLER_19_179 VPWR VGND sg13g2_decap_8
XFILLER_19_81 VPWR VGND sg13g2_decap_8
XFILLER_34_105 VPWR VGND sg13g2_decap_8
XFILLER_47_455 VPWR VGND sg13g2_decap_8
XFILLER_11_580 VPWR VGND sg13g2_fill_1
XFILLER_30_333 VPWR VGND sg13g2_decap_8
XFILLER_35_91 VPWR VGND sg13g2_decap_8
X_0712_ net77 VPWR _0445_ VGND net55 state\[62\] sg13g2_o21ai_1
X_0643_ net91 VPWR _0393_ VGND net70 state\[45\] sg13g2_o21ai_1
X_0574_ _0091_ _0340_ _0341_ net39 _0220_ VPWR VGND sg13g2_a22oi_1
XFILLER_38_455 VPWR VGND sg13g2_decap_8
XFILLER_19_680 VPWR VGND sg13g2_fill_1
XFILLER_21_344 VPWR VGND sg13g2_decap_8
XFILLER_25_149 VPWR VGND sg13g2_decap_8
XFILLER_33_193 VPWR VGND sg13g2_decap_8
XFILLER_31_16 VPWR VGND sg13g2_decap_8
XFILLER_0_259 VPWR VGND sg13g2_decap_8
Xoutput16 net16 uo_out[1] VPWR VGND sg13g2_buf_1
XFILLER_16_116 VPWR VGND sg13g2_decap_8
XFILLER_17_617 VPWR VGND sg13g2_decap_8
XFILLER_29_433 VPWR VGND sg13g2_decap_8
XFILLER_44_436 VPWR VGND sg13g2_decap_8
XFILLER_12_300 VPWR VGND sg13g2_decap_8
XFILLER_12_377 VPWR VGND sg13g2_decap_8
XFILLER_24_182 VPWR VGND sg13g2_decap_8
XFILLER_21_71 VPWR VGND sg13g2_decap_8
XFILLER_39_208 VPWR VGND sg13g2_decap_8
XFILLER_47_252 VPWR VGND sg13g2_decap_8
XFILLER_16_694 VPWR VGND sg13g2_decap_8
XFILLER_22_119 VPWR VGND sg13g2_decap_8
XFILLER_30_130 VPWR VGND sg13g2_decap_8
XFILLER_31_653 VPWR VGND sg13g2_decap_8
XFILLER_35_469 VPWR VGND sg13g2_decap_8
Xclkbuf_0_clk clknet_0_clk clk VPWR VGND sg13g2_buf_16
XFILLER_7_84 VPWR VGND sg13g2_decap_8
XFILLER_7_392 VPWR VGND sg13g2_decap_8
X_0626_ _0104_ _0379_ _0380_ net51 _0233_ VPWR VGND sg13g2_a22oi_1
X_0557_ VGND VPWR net25 daisychain\[22\] _0329_ net41 sg13g2_a21oi_1
XFILLER_26_469 VPWR VGND sg13g2_decap_8
XFILLER_26_49 VPWR VGND sg13g2_decap_8
XFILLER_38_252 VPWR VGND sg13g2_decap_8
X_0488_ _0199_ net59 _0276_ _0277_ VPWR VGND sg13g2_a21o_1
XFILLER_21_141 VPWR VGND sg13g2_decap_8
XFILLER_22_686 VPWR VGND sg13g2_decap_8
XFILLER_1_546 VPWR VGND sg13g2_decap_8
XFILLER_29_230 VPWR VGND sg13g2_decap_8
XFILLER_45_712 VPWR VGND sg13g2_fill_2
XFILLER_16_60 VPWR VGND sg13g2_decap_8
XFILLER_17_414 VPWR VGND sg13g2_decap_8
XFILLER_32_417 VPWR VGND sg13g2_decap_8
XFILLER_44_233 VPWR VGND sg13g2_decap_8
XFILLER_12_174 VPWR VGND sg13g2_decap_8
XFILLER_32_81 VPWR VGND sg13g2_decap_8
XFILLER_9_635 VPWR VGND sg13g2_decap_8
XFILLER_8_167 VPWR VGND sg13g2_decap_8
XFILLER_4_340 VPWR VGND sg13g2_decap_8
XFILLER_16_480 VPWR VGND sg13g2_decap_8
XFILLER_23_428 VPWR VGND sg13g2_decap_8
XFILLER_31_450 VPWR VGND sg13g2_decap_8
XFILLER_35_266 VPWR VGND sg13g2_decap_8
XFILLER_8_690 VPWR VGND sg13g2_fill_2
X_0609_ VGND VPWR net27 daisychain\[35\] _0368_ net48 sg13g2_a21oi_1
XFILLER_26_266 VPWR VGND sg13g2_decap_8
XFILLER_27_734 VPWR VGND sg13g2_decap_8
XFILLER_39_583 VPWR VGND sg13g2_decap_8
XFILLER_22_483 VPWR VGND sg13g2_decap_8
XFILLER_41_258 VPWR VGND sg13g2_decap_8
XFILLER_5_137 VPWR VGND sg13g2_decap_8
XFILLER_1_343 VPWR VGND sg13g2_decap_8
XFILLER_17_211 VPWR VGND sg13g2_decap_8
XFILLER_18_701 VPWR VGND sg13g2_decap_8
XFILLER_45_553 VPWR VGND sg13g2_decap_8
XFILLER_49_347 VPWR VGND sg13g2_decap_8
XFILLER_13_450 VPWR VGND sg13g2_decap_8
XFILLER_17_288 VPWR VGND sg13g2_decap_8
XFILLER_20_409 VPWR VGND sg13g2_decap_8
XFILLER_32_214 VPWR VGND sg13g2_decap_8
X_0960_ net117 VGND VPWR _0120_ daisychain\[56\] clknet_5_24__leaf_clk sg13g2_dfrbpq_1
XFILLER_9_410 VPWR VGND sg13g2_decap_8
X_0891_ VPWR _0245_ daisychain\[52\] VGND sg13g2_inv_1
XFILLER_9_487 VPWR VGND sg13g2_decap_8
XFILLER_4_74 VPWR VGND sg13g2_decap_8
XFILLER_23_225 VPWR VGND sg13g2_decap_8
XFILLER_24_748 VPWR VGND sg13g2_fill_2
XFILLER_24_759 VPWR VGND sg13g2_fill_2
XFILLER_36_553 VPWR VGND sg13g2_decap_8
XFILLER_23_28 VPWR VGND sg13g2_fill_2
XFILLER_48_14 VPWR VGND sg13g2_decap_8
XFILLER_27_531 VPWR VGND sg13g2_decap_8
XFILLER_14_247 VPWR VGND sg13g2_decap_8
XFILLER_15_759 VPWR VGND sg13g2_fill_1
XFILLER_42_567 VPWR VGND sg13g2_decap_8
Xfanout73 net74 net73 VPWR VGND sg13g2_buf_1
Xfanout62 net66 net62 VPWR VGND sg13g2_buf_1
Xfanout51 net53 net51 VPWR VGND sg13g2_buf_1
Xfanout40 net45 net40 VPWR VGND sg13g2_buf_1
XFILLER_10_475 VPWR VGND sg13g2_decap_8
XFILLER_13_72 VPWR VGND sg13g2_decap_8
XFILLER_22_280 VPWR VGND sg13g2_decap_8
Xfanout95 net96 net95 VPWR VGND sg13g2_buf_1
Xfanout84 net86 net84 VPWR VGND sg13g2_buf_1
XFILLER_6_435 VPWR VGND sg13g2_decap_8
XFILLER_1_140 VPWR VGND sg13g2_decap_8
XFILLER_29_8 VPWR VGND sg13g2_fill_1
XFILLER_2_696 VPWR VGND sg13g2_decap_8
XFILLER_49_144 VPWR VGND sg13g2_decap_8
XFILLER_18_553 VPWR VGND sg13g2_decap_8
XFILLER_33_501 VPWR VGND sg13g2_decap_8
XFILLER_38_91 VPWR VGND sg13g2_decap_8
XFILLER_45_350 VPWR VGND sg13g2_decap_8
Xclkbuf_5_24__f_clk clknet_5_24__leaf_clk clknet_4_12_0_clk VPWR VGND sg13g2_buf_16
XFILLER_14_781 VPWR VGND sg13g2_fill_1
XFILLER_14_792 VPWR VGND sg13g2_fill_2
XFILLER_20_206 VPWR VGND sg13g2_decap_8
XFILLER_21_707 VPWR VGND sg13g2_fill_2
XFILLER_33_578 VPWR VGND sg13g2_decap_8
X_0874_ VPWR _0003_ state\[44\] VGND sg13g2_inv_1
X_0943_ net114 VGND VPWR _0103_ daisychain\[39\] clknet_5_29__leaf_clk sg13g2_dfrbpq_1
XFILLER_9_284 VPWR VGND sg13g2_decap_8
XFILLER_48_0 VPWR VGND sg13g2_decap_8
XFILLER_11_228 VPWR VGND sg13g2_decap_8
XFILLER_24_567 VPWR VGND sg13g2_decap_8
XFILLER_34_49 VPWR VGND sg13g2_decap_8
XFILLER_36_350 VPWR VGND sg13g2_decap_8
XFILLER_3_438 VPWR VGND sg13g2_decap_8
XFILLER_15_534 VPWR VGND sg13g2_decap_8
XFILLER_46_147 VPWR VGND sg13g2_decap_8
XFILLER_30_515 VPWR VGND sg13g2_decap_8
XFILLER_42_364 VPWR VGND sg13g2_decap_8
XFILLER_10_272 VPWR VGND sg13g2_decap_8
XFILLER_40_92 VPWR VGND sg13g2_decap_8
X_0590_ _0095_ _0352_ _0353_ net41 _0224_ VPWR VGND sg13g2_a22oi_1
XFILLER_6_232 VPWR VGND sg13g2_decap_8
XFILLER_1_42 VPWR VGND sg13g2_decap_8
XFILLER_37_147 VPWR VGND sg13g2_decap_8
XFILLER_18_350 VPWR VGND sg13g2_decap_8
XFILLER_21_526 VPWR VGND sg13g2_decap_8
XFILLER_33_375 VPWR VGND sg13g2_decap_8
XFILLER_20_18 VPWR VGND sg13g2_fill_2
X_0857_ VPWR _0228_ daisychain\[35\] VGND sg13g2_inv_1
X_0926_ net107 VGND VPWR _0086_ daisychain\[22\] clknet_5_12__leaf_clk sg13g2_dfrbpq_1
XFILLER_29_27 VPWR VGND sg13g2_decap_8
X_0788_ VPWR _0043_ state\[1\] VGND sg13g2_inv_1
XFILLER_25_821 VPWR VGND sg13g2_fill_2
XFILLER_28_158 VPWR VGND sg13g2_decap_8
XFILLER_29_615 VPWR VGND sg13g2_decap_8
XFILLER_12_559 VPWR VGND sg13g2_decap_8
XFILLER_20_570 VPWR VGND sg13g2_decap_8
XFILLER_24_364 VPWR VGND sg13g2_decap_8
XFILLER_10_62 VPWR VGND sg13g2_decap_8
XFILLER_3_235 VPWR VGND sg13g2_decap_8
XFILLER_19_60 VPWR VGND sg13g2_decap_8
XFILLER_47_434 VPWR VGND sg13g2_decap_8
XFILLER_15_331 VPWR VGND sg13g2_decap_8
XFILLER_19_158 VPWR VGND sg13g2_decap_8
XFILLER_30_312 VPWR VGND sg13g2_decap_8
XFILLER_35_70 VPWR VGND sg13g2_decap_8
XFILLER_11_592 VPWR VGND sg13g2_decap_8
XFILLER_30_389 VPWR VGND sg13g2_decap_8
X_0711_ daisychain\[62\] net55 _0444_ VPWR VGND sg13g2_nor2b_1
XFILLER_3_780 VPWR VGND sg13g2_fill_1
XFILLER_3_791 VPWR VGND sg13g2_fill_2
X_0642_ _0108_ _0391_ _0392_ net50 _0237_ VPWR VGND sg13g2_a22oi_1
X_0573_ VGND VPWR net23 daisychain\[26\] _0341_ net38 sg13g2_a21oi_1
XFILLER_25_128 VPWR VGND sg13g2_decap_8
XFILLER_38_434 VPWR VGND sg13g2_decap_8
XFILLER_21_323 VPWR VGND sg13g2_decap_8
XFILLER_33_172 VPWR VGND sg13g2_decap_8
XFILLER_34_651 VPWR VGND sg13g2_decap_8
XFILLER_34_662 VPWR VGND sg13g2_fill_1
X_0909_ net100 VGND VPWR _0069_ daisychain\[5\] clknet_5_0__leaf_clk sg13g2_dfrbpq_1
Xoutput17 net17 uo_out[2] VPWR VGND sg13g2_buf_1
XFILLER_0_238 VPWR VGND sg13g2_decap_8
XFILLER_29_412 VPWR VGND sg13g2_decap_8
XFILLER_24_161 VPWR VGND sg13g2_decap_8
XFILLER_25_684 VPWR VGND sg13g2_decap_8
XFILLER_29_489 VPWR VGND sg13g2_decap_8
XFILLER_44_415 VPWR VGND sg13g2_decap_8
XFILLER_12_356 VPWR VGND sg13g2_decap_8
XFILLER_40_654 VPWR VGND sg13g2_fill_1
XFILLER_8_349 VPWR VGND sg13g2_decap_8
XFILLER_0_750 VPWR VGND sg13g2_decap_8
XFILLER_21_50 VPWR VGND sg13g2_decap_8
XFILLER_4_522 VPWR VGND sg13g2_decap_8
XFILLER_0_761 VPWR VGND sg13g2_fill_2
XFILLER_47_231 VPWR VGND sg13g2_decap_8
XFILLER_16_662 VPWR VGND sg13g2_fill_1
XFILLER_31_632 VPWR VGND sg13g2_decap_8
XFILLER_35_448 VPWR VGND sg13g2_decap_8
XFILLER_46_91 VPWR VGND sg13g2_decap_8
XFILLER_30_186 VPWR VGND sg13g2_decap_8
X_0625_ VGND VPWR net28 daisychain\[39\] _0380_ net51 sg13g2_a21oi_1
XFILLER_7_63 VPWR VGND sg13g2_decap_8
XFILLER_7_371 VPWR VGND sg13g2_decap_8
X_0556_ _0216_ net65 _0327_ _0328_ VPWR VGND sg13g2_a21o_1
X_0487_ net80 VPWR _0276_ VGND net59 state\[6\] sg13g2_o21ai_1
XFILLER_26_28 VPWR VGND sg13g2_decap_8
XFILLER_26_448 VPWR VGND sg13g2_decap_8
XFILLER_38_231 VPWR VGND sg13g2_decap_8
XFILLER_21_120 VPWR VGND sg13g2_decap_8
XFILLER_21_197 VPWR VGND sg13g2_decap_8
XFILLER_22_665 VPWR VGND sg13g2_decap_8
XFILLER_5_319 VPWR VGND sg13g2_decap_8
XFILLER_1_525 VPWR VGND sg13g2_decap_8
XFILLER_29_286 VPWR VGND sg13g2_decap_8
XFILLER_44_212 VPWR VGND sg13g2_decap_8
Xclkbuf_5_5__f_clk clknet_5_5__leaf_clk clknet_4_2_0_clk VPWR VGND sg13g2_buf_16
XFILLER_49_529 VPWR VGND sg13g2_decap_8
XFILLER_12_153 VPWR VGND sg13g2_decap_8
XFILLER_25_481 VPWR VGND sg13g2_decap_8
XFILLER_44_289 VPWR VGND sg13g2_decap_8
XFILLER_9_614 VPWR VGND sg13g2_decap_8
XFILLER_32_60 VPWR VGND sg13g2_decap_8
XFILLER_40_484 VPWR VGND sg13g2_decap_8
XFILLER_9_669 VPWR VGND sg13g2_decap_8
XFILLER_8_146 VPWR VGND sg13g2_decap_8
XFILLER_4_396 VPWR VGND sg13g2_decap_8
XFILLER_23_407 VPWR VGND sg13g2_decap_8
XFILLER_35_245 VPWR VGND sg13g2_decap_8
XFILLER_48_595 VPWR VGND sg13g2_decap_8
X_0608_ _0229_ net68 _0366_ _0367_ VPWR VGND sg13g2_a21o_1
XFILLER_27_713 VPWR VGND sg13g2_decap_8
XFILLER_37_49 VPWR VGND sg13g2_decap_8
XFILLER_39_562 VPWR VGND sg13g2_decap_8
X_0539_ net84 VPWR _0315_ VGND net63 state\[19\] sg13g2_o21ai_1
XFILLER_14_429 VPWR VGND sg13g2_decap_8
XFILLER_22_462 VPWR VGND sg13g2_decap_8
XFILLER_26_245 VPWR VGND sg13g2_decap_8
XFILLER_41_237 VPWR VGND sg13g2_decap_8
XFILLER_10_668 VPWR VGND sg13g2_fill_1
XFILLER_5_116 VPWR VGND sg13g2_decap_8
XFILLER_1_322 VPWR VGND sg13g2_decap_8
XFILLER_1_399 VPWR VGND sg13g2_decap_8
XFILLER_2_812 VPWR VGND sg13g2_decap_8
XFILLER_49_326 VPWR VGND sg13g2_decap_8
XFILLER_17_267 VPWR VGND sg13g2_decap_8
XFILLER_45_532 VPWR VGND sg13g2_decap_8
XFILLER_40_281 VPWR VGND sg13g2_decap_8
XFILLER_43_81 VPWR VGND sg13g2_decap_8
X_0890_ VPWR _0012_ state\[52\] VGND sg13g2_inv_1
XFILLER_9_466 VPWR VGND sg13g2_decap_8
XFILLER_4_193 VPWR VGND sg13g2_decap_8
XFILLER_4_53 VPWR VGND sg13g2_decap_8
XFILLER_23_18 VPWR VGND sg13g2_fill_1
XFILLER_23_204 VPWR VGND sg13g2_decap_8
XFILLER_36_532 VPWR VGND sg13g2_decap_8
XFILLER_48_392 VPWR VGND sg13g2_decap_8
XFILLER_3_609 VPWR VGND sg13g2_fill_1
XFILLER_27_510 VPWR VGND sg13g2_decap_8
XFILLER_27_587 VPWR VGND sg13g2_decap_8
XFILLER_46_329 VPWR VGND sg13g2_decap_8
XFILLER_13_51 VPWR VGND sg13g2_decap_8
XFILLER_14_226 VPWR VGND sg13g2_decap_8
XFILLER_23_793 VPWR VGND sg13g2_fill_1
XFILLER_42_546 VPWR VGND sg13g2_decap_8
Xfanout30 net31 net30 VPWR VGND sg13g2_buf_1
Xfanout96 net4 net96 VPWR VGND sg13g2_buf_1
Xfanout85 net86 net85 VPWR VGND sg13g2_buf_1
Xfanout74 net75 net74 VPWR VGND sg13g2_buf_1
Xfanout63 net65 net63 VPWR VGND sg13g2_buf_1
Xfanout52 net53 net52 VPWR VGND sg13g2_buf_1
Xfanout41 net44 net41 VPWR VGND sg13g2_buf_1
XFILLER_10_454 VPWR VGND sg13g2_decap_8
XFILLER_6_414 VPWR VGND sg13g2_decap_8
XFILLER_1_196 VPWR VGND sg13g2_decap_8
XFILLER_37_329 VPWR VGND sg13g2_decap_8
XFILLER_38_70 VPWR VGND sg13g2_decap_8
XFILLER_49_123 VPWR VGND sg13g2_decap_8
XFILLER_18_532 VPWR VGND sg13g2_decap_8
XFILLER_33_557 VPWR VGND sg13g2_decap_8
X_0873_ VPWR _0236_ daisychain\[43\] VGND sg13g2_inv_1
X_0942_ net109 VGND VPWR _0102_ daisychain\[38\] clknet_5_31__leaf_clk sg13g2_dfrbpq_1
XFILLER_9_263 VPWR VGND sg13g2_decap_8
XFILLER_5_480 VPWR VGND sg13g2_decap_8
XFILLER_49_690 VPWR VGND sg13g2_decap_8
XFILLER_11_207 VPWR VGND sg13g2_decap_8
XFILLER_24_546 VPWR VGND sg13g2_decap_8
XFILLER_34_28 VPWR VGND sg13g2_decap_8
XFILLER_3_417 VPWR VGND sg13g2_decap_8
Xclkbuf_5_30__f_clk clknet_5_30__leaf_clk clknet_4_15_0_clk VPWR VGND sg13g2_buf_16
XFILLER_1_7 VPWR VGND sg13g2_decap_8
XFILLER_47_616 VPWR VGND sg13g2_decap_8
XFILLER_15_513 VPWR VGND sg13g2_decap_8
XFILLER_27_384 VPWR VGND sg13g2_decap_8
XFILLER_42_343 VPWR VGND sg13g2_decap_8
XFILLER_46_126 VPWR VGND sg13g2_decap_8
XFILLER_10_251 VPWR VGND sg13g2_decap_8
XFILLER_6_211 VPWR VGND sg13g2_decap_8
XFILLER_34_7 VPWR VGND sg13g2_decap_8
XFILLER_40_71 VPWR VGND sg13g2_decap_8
XFILLER_6_288 VPWR VGND sg13g2_decap_8
XFILLER_1_21 VPWR VGND sg13g2_decap_8
XFILLER_1_98 VPWR VGND sg13g2_decap_8
XFILLER_2_494 VPWR VGND sg13g2_decap_8
XFILLER_34_811 VPWR VGND sg13g2_decap_8
XFILLER_37_126 VPWR VGND sg13g2_decap_8
XFILLER_14_590 VPWR VGND sg13g2_decap_8
XFILLER_21_505 VPWR VGND sg13g2_decap_8
XFILLER_33_354 VPWR VGND sg13g2_decap_8
XFILLER_34_822 VPWR VGND sg13g2_fill_1
X_0856_ VPWR _0025_ state\[35\] VGND sg13g2_inv_1
X_0925_ net107 VGND VPWR _0085_ daisychain\[21\] clknet_5_14__leaf_clk sg13g2_dfrbpq_1
X_0787_ VPWR _0193_ daisychain\[0\] VGND sg13g2_inv_1
XFILLER_24_343 VPWR VGND sg13g2_decap_8
XFILLER_25_800 VPWR VGND sg13g2_decap_8
XFILLER_28_137 VPWR VGND sg13g2_decap_8
XFILLER_45_49 VPWR VGND sg13g2_decap_8
XFILLER_12_538 VPWR VGND sg13g2_decap_8
XFILLER_10_41 VPWR VGND sg13g2_decap_8
XFILLER_3_214 VPWR VGND sg13g2_decap_8
XFILLER_19_137 VPWR VGND sg13g2_decap_8
XFILLER_47_413 VPWR VGND sg13g2_decap_8
XFILLER_15_310 VPWR VGND sg13g2_decap_8
XFILLER_15_387 VPWR VGND sg13g2_decap_8
XFILLER_16_822 VPWR VGND sg13g2_fill_1
XFILLER_27_181 VPWR VGND sg13g2_decap_8
XFILLER_43_674 VPWR VGND sg13g2_decap_4
XFILLER_11_571 VPWR VGND sg13g2_decap_8
XFILLER_30_368 VPWR VGND sg13g2_decap_8
X_0710_ _0125_ _0442_ _0443_ net34 _0254_ VPWR VGND sg13g2_a22oi_1
X_0641_ VGND VPWR net28 daisychain\[43\] _0392_ net50 sg13g2_a21oi_1
XFILLER_7_553 VPWR VGND sg13g2_decap_4
XFILLER_2_291 VPWR VGND sg13g2_decap_8
XFILLER_32_4 VPWR VGND sg13g2_decap_8
XFILLER_38_413 VPWR VGND sg13g2_decap_8
X_0572_ _0220_ net58 _0339_ _0340_ VPWR VGND sg13g2_a21o_1
XFILLER_25_107 VPWR VGND sg13g2_decap_8
XFILLER_34_630 VPWR VGND sg13g2_decap_8
XFILLER_46_490 VPWR VGND sg13g2_decap_8
X_1055_ daisychain\[63\] net22 VPWR VGND sg13g2_buf_1
XFILLER_21_302 VPWR VGND sg13g2_decap_8
XFILLER_21_379 VPWR VGND sg13g2_decap_8
XFILLER_33_151 VPWR VGND sg13g2_decap_8
XFILLER_34_685 VPWR VGND sg13g2_fill_1
XFILLER_0_217 VPWR VGND sg13g2_decap_8
X_0908_ net99 VGND VPWR _0068_ daisychain\[4\] clknet_5_0__leaf_clk sg13g2_dfrbpq_1
Xoutput18 net18 uo_out[3] VPWR VGND sg13g2_buf_1
X_0839_ VPWR _0219_ daisychain\[26\] VGND sg13g2_inv_1
XFILLER_29_468 VPWR VGND sg13g2_decap_8
XFILLER_12_335 VPWR VGND sg13g2_decap_8
XFILLER_24_140 VPWR VGND sg13g2_decap_8
XFILLER_25_663 VPWR VGND sg13g2_decap_8
XFILLER_37_490 VPWR VGND sg13g2_decap_8
XFILLER_8_328 VPWR VGND sg13g2_decap_8
XFILLER_4_501 VPWR VGND sg13g2_decap_8
XFILLER_35_427 VPWR VGND sg13g2_decap_8
XFILLER_46_70 VPWR VGND sg13g2_decap_8
XFILLER_47_210 VPWR VGND sg13g2_decap_8
XFILLER_47_287 VPWR VGND sg13g2_decap_8
XFILLER_15_184 VPWR VGND sg13g2_decap_8
XFILLER_16_674 VPWR VGND sg13g2_fill_2
XFILLER_30_165 VPWR VGND sg13g2_decap_8
XFILLER_31_611 VPWR VGND sg13g2_decap_8
X_0624_ _0233_ net71 _0378_ _0379_ VPWR VGND sg13g2_a21o_1
XFILLER_7_42 VPWR VGND sg13g2_decap_8
XFILLER_7_350 VPWR VGND sg13g2_decap_8
XFILLER_38_210 VPWR VGND sg13g2_decap_8
X_0555_ net86 VPWR _0327_ VGND net65 state\[23\] sg13g2_o21ai_1
X_0486_ _0069_ _0274_ _0275_ net38 _0198_ VPWR VGND sg13g2_a22oi_1
XFILLER_22_644 VPWR VGND sg13g2_decap_8
XFILLER_26_427 VPWR VGND sg13g2_decap_8
XFILLER_38_287 VPWR VGND sg13g2_decap_8
XFILLER_41_419 VPWR VGND sg13g2_decap_8
XFILLER_21_176 VPWR VGND sg13g2_decap_8
XFILLER_1_504 VPWR VGND sg13g2_decap_8
XFILLER_49_508 VPWR VGND sg13g2_decap_8
XFILLER_17_449 VPWR VGND sg13g2_decap_8
XFILLER_29_265 VPWR VGND sg13g2_decap_8
XFILLER_45_703 VPWR VGND sg13g2_fill_2
XFILLER_12_132 VPWR VGND sg13g2_decap_8
XFILLER_13_655 VPWR VGND sg13g2_fill_2
XFILLER_16_95 VPWR VGND sg13g2_decap_8
XFILLER_25_460 VPWR VGND sg13g2_decap_8
XFILLER_40_463 VPWR VGND sg13g2_decap_8
XFILLER_44_268 VPWR VGND sg13g2_decap_8
XFILLER_8_125 VPWR VGND sg13g2_decap_8
XFILLER_4_375 VPWR VGND sg13g2_decap_8
XFILLER_0_581 VPWR VGND sg13g2_decap_8
XFILLER_35_224 VPWR VGND sg13g2_decap_8
XFILLER_48_574 VPWR VGND sg13g2_decap_8
XFILLER_31_485 VPWR VGND sg13g2_decap_8
X_0607_ net89 VPWR _0366_ VGND net68 state\[36\] sg13g2_o21ai_1
X_0538_ _0082_ _0313_ _0314_ net42 _0211_ VPWR VGND sg13g2_a22oi_1
XFILLER_26_224 VPWR VGND sg13g2_decap_8
XFILLER_37_28 VPWR VGND sg13g2_decap_8
X_0469_ VGND VPWR net32 daisychain\[0\] _0263_ net36 sg13g2_a21oi_1
XFILLER_10_614 VPWR VGND sg13g2_fill_2
XFILLER_14_408 VPWR VGND sg13g2_decap_8
XFILLER_22_441 VPWR VGND sg13g2_decap_8
XFILLER_41_216 VPWR VGND sg13g2_decap_8
XFILLER_1_301 VPWR VGND sg13g2_decap_8
XFILLER_6_629 VPWR VGND sg13g2_fill_1
XFILLER_1_378 VPWR VGND sg13g2_decap_8
XFILLER_49_305 VPWR VGND sg13g2_decap_8
XFILLER_17_246 VPWR VGND sg13g2_decap_8
XFILLER_27_83 VPWR VGND sg13g2_decap_8
XFILLER_33_717 VPWR VGND sg13g2_fill_2
XFILLER_45_511 VPWR VGND sg13g2_decap_8
XFILLER_45_588 VPWR VGND sg13g2_decap_8
XFILLER_13_485 VPWR VGND sg13g2_decap_8
XFILLER_32_249 VPWR VGND sg13g2_decap_8
XFILLER_40_260 VPWR VGND sg13g2_decap_8
XFILLER_43_60 VPWR VGND sg13g2_decap_8
XFILLER_9_445 VPWR VGND sg13g2_decap_8
XFILLER_4_32 VPWR VGND sg13g2_decap_8
XFILLER_4_172 VPWR VGND sg13g2_decap_8
XFILLER_36_511 VPWR VGND sg13g2_decap_8
XFILLER_48_371 VPWR VGND sg13g2_decap_8
XFILLER_32_772 VPWR VGND sg13g2_decap_8
XFILLER_36_588 VPWR VGND sg13g2_decap_8
XFILLER_2_109 VPWR VGND sg13g2_decap_8
XFILLER_31_282 VPWR VGND sg13g2_decap_8
XFILLER_48_49 VPWR VGND sg13g2_decap_8
XFILLER_14_205 VPWR VGND sg13g2_decap_8
XFILLER_27_566 VPWR VGND sg13g2_decap_8
XFILLER_42_525 VPWR VGND sg13g2_decap_8
XFILLER_46_308 VPWR VGND sg13g2_decap_8
XFILLER_10_433 VPWR VGND sg13g2_decap_8
XFILLER_13_30 VPWR VGND sg13g2_decap_8
Xfanout31 net32 net31 VPWR VGND sg13g2_buf_1
Xfanout97 net1 net97 VPWR VGND sg13g2_buf_1
Xfanout86 net87 net86 VPWR VGND sg13g2_buf_1
Xfanout75 net5 net75 VPWR VGND sg13g2_buf_1
Xfanout64 net65 net64 VPWR VGND sg13g2_buf_1
Xfanout53 net54 net53 VPWR VGND sg13g2_buf_1
Xfanout42 net44 net42 VPWR VGND sg13g2_buf_1
XFILLER_2_665 VPWR VGND sg13g2_decap_8
XFILLER_18_511 VPWR VGND sg13g2_decap_8
XFILLER_1_175 VPWR VGND sg13g2_decap_8
XFILLER_37_308 VPWR VGND sg13g2_decap_8
XFILLER_49_179 VPWR VGND sg13g2_decap_8
XFILLER_49_102 VPWR VGND sg13g2_decap_8
XFILLER_18_588 VPWR VGND sg13g2_decap_8
XFILLER_33_536 VPWR VGND sg13g2_decap_8
XFILLER_45_385 VPWR VGND sg13g2_decap_8
X_0941_ net109 VGND VPWR _0101_ daisychain\[37\] clknet_5_31__leaf_clk sg13g2_dfrbpq_1
XFILLER_13_282 VPWR VGND sg13g2_decap_8
X_0872_ VPWR _0002_ state\[43\] VGND sg13g2_inv_1
XFILLER_9_242 VPWR VGND sg13g2_decap_8
XFILLER_24_525 VPWR VGND sg13g2_decap_8
XFILLER_28_319 VPWR VGND sg13g2_decap_8
XFILLER_36_385 VPWR VGND sg13g2_decap_8
XFILLER_19_319 VPWR VGND sg13g2_decap_8
XFILLER_46_105 VPWR VGND sg13g2_decap_8
XFILLER_27_363 VPWR VGND sg13g2_decap_8
XFILLER_42_322 VPWR VGND sg13g2_decap_8
XFILLER_10_230 VPWR VGND sg13g2_decap_8
XFILLER_24_84 VPWR VGND sg13g2_decap_8
XFILLER_40_50 VPWR VGND sg13g2_decap_8
XFILLER_42_399 VPWR VGND sg13g2_decap_8
XFILLER_6_267 VPWR VGND sg13g2_decap_8
XFILLER_27_7 VPWR VGND sg13g2_decap_8
XFILLER_2_473 VPWR VGND sg13g2_decap_8
XFILLER_41_9 VPWR VGND sg13g2_decap_4
XFILLER_49_81 VPWR VGND sg13g2_decap_8
XFILLER_18_385 VPWR VGND sg13g2_decap_8
XFILLER_19_820 VPWR VGND sg13g2_fill_2
XFILLER_1_77 VPWR VGND sg13g2_decap_8
XFILLER_37_105 VPWR VGND sg13g2_decap_8
XFILLER_33_333 VPWR VGND sg13g2_decap_8
XFILLER_45_182 VPWR VGND sg13g2_decap_8
X_0924_ net107 VGND VPWR _0084_ daisychain\[20\] clknet_5_16__leaf_clk sg13g2_dfrbpq_1
X_0855_ VPWR _0227_ daisychain\[34\] VGND sg13g2_inv_1
X_0786_ VPWR _0032_ state\[0\] VGND sg13g2_inv_1
XFILLER_28_116 VPWR VGND sg13g2_decap_8
XFILLER_12_517 VPWR VGND sg13g2_decap_8
XFILLER_24_322 VPWR VGND sg13g2_decap_8
XFILLER_36_182 VPWR VGND sg13g2_decap_8
XFILLER_45_28 VPWR VGND sg13g2_decap_8
XFILLER_24_399 VPWR VGND sg13g2_decap_8
XFILLER_10_20 VPWR VGND sg13g2_decap_8
XFILLER_10_97 VPWR VGND sg13g2_decap_8
XFILLER_19_116 VPWR VGND sg13g2_decap_8
XFILLER_19_95 VPWR VGND sg13g2_decap_8
XFILLER_27_160 VPWR VGND sg13g2_decap_8
XFILLER_28_683 VPWR VGND sg13g2_decap_8
XFILLER_34_119 VPWR VGND sg13g2_decap_8
XFILLER_35_609 VPWR VGND sg13g2_decap_8
XFILLER_47_469 VPWR VGND sg13g2_decap_8
XFILLER_11_550 VPWR VGND sg13g2_decap_8
XFILLER_15_366 VPWR VGND sg13g2_decap_8
XFILLER_30_347 VPWR VGND sg13g2_decap_8
XFILLER_31_804 VPWR VGND sg13g2_decap_8
XFILLER_31_815 VPWR VGND sg13g2_fill_1
XFILLER_42_163 VPWR VGND sg13g2_decap_8
XFILLER_42_174 VPWR VGND sg13g2_fill_2
XFILLER_43_631 VPWR VGND sg13g2_fill_1
X_0640_ _0237_ net70 _0390_ _0391_ VPWR VGND sg13g2_a21o_1
X_0571_ net79 VPWR _0339_ VGND net58 state\[27\] sg13g2_o21ai_1
XFILLER_7_532 VPWR VGND sg13g2_decap_8
XFILLER_25_4 VPWR VGND sg13g2_fill_2
XFILLER_2_270 VPWR VGND sg13g2_decap_8
XFILLER_3_793 VPWR VGND sg13g2_fill_1
XFILLER_18_182 VPWR VGND sg13g2_decap_8
XFILLER_26_609 VPWR VGND sg13g2_decap_8
XFILLER_33_130 VPWR VGND sg13g2_decap_8
XFILLER_38_469 VPWR VGND sg13g2_decap_8
X_1054_ daisychain\[62\] net21 VPWR VGND sg13g2_buf_1
XFILLER_21_358 VPWR VGND sg13g2_decap_8
X_0907_ net99 VGND VPWR _0067_ daisychain\[3\] clknet_5_3__leaf_clk sg13g2_dfrbpq_1
Xoutput19 net19 uo_out[4] VPWR VGND sg13g2_buf_1
X_0838_ VPWR _0050_ state\[26\] VGND sg13g2_inv_1
X_0769_ _0406_ VPWR _0177_ VGND net94 _0008_ sg13g2_o21ai_1
XFILLER_29_447 VPWR VGND sg13g2_decap_8
XFILLER_12_314 VPWR VGND sg13g2_decap_8
XFILLER_24_196 VPWR VGND sg13g2_decap_8
XFILLER_25_642 VPWR VGND sg13g2_decap_8
XFILLER_8_307 VPWR VGND sg13g2_decap_8
XFILLER_21_85 VPWR VGND sg13g2_decap_8
XFILLER_16_620 VPWR VGND sg13g2_decap_8
XFILLER_28_480 VPWR VGND sg13g2_decap_8
XFILLER_35_406 VPWR VGND sg13g2_decap_8
XFILLER_47_266 VPWR VGND sg13g2_decap_8
XFILLER_15_163 VPWR VGND sg13g2_decap_8
XFILLER_30_144 VPWR VGND sg13g2_decap_8
XFILLER_31_667 VPWR VGND sg13g2_decap_8
XFILLER_7_21 VPWR VGND sg13g2_decap_8
X_0623_ net92 VPWR _0378_ VGND net71 state\[40\] sg13g2_o21ai_1
X_0554_ _0086_ _0325_ _0326_ net41 _0215_ VPWR VGND sg13g2_a22oi_1
XFILLER_7_98 VPWR VGND sg13g2_decap_8
XFILLER_26_406 VPWR VGND sg13g2_decap_8
XFILLER_38_266 VPWR VGND sg13g2_decap_8
XFILLER_39_701 VPWR VGND sg13g2_fill_2
X_0485_ VGND VPWR net23 daisychain\[4\] _0275_ net38 sg13g2_a21oi_1
XFILLER_19_480 VPWR VGND sg13g2_decap_8
XFILLER_22_623 VPWR VGND sg13g2_decap_8
XFILLER_34_483 VPWR VGND sg13g2_decap_8
XFILLER_21_155 VPWR VGND sg13g2_decap_8
XFILLER_17_428 VPWR VGND sg13g2_decap_8
XFILLER_29_244 VPWR VGND sg13g2_decap_8
XFILLER_44_247 VPWR VGND sg13g2_decap_8
XFILLER_12_111 VPWR VGND sg13g2_decap_8
XFILLER_12_188 VPWR VGND sg13g2_decap_8
XFILLER_16_74 VPWR VGND sg13g2_decap_8
XFILLER_40_442 VPWR VGND sg13g2_decap_8
XFILLER_8_104 VPWR VGND sg13g2_decap_8
XFILLER_32_95 VPWR VGND sg13g2_decap_8
XFILLER_4_354 VPWR VGND sg13g2_decap_8
XFILLER_0_560 VPWR VGND sg13g2_decap_8
XFILLER_35_203 VPWR VGND sg13g2_decap_8
XFILLER_48_553 VPWR VGND sg13g2_decap_8
XFILLER_31_464 VPWR VGND sg13g2_decap_8
X_0606_ _0099_ _0364_ _0365_ net47 _0228_ VPWR VGND sg13g2_a22oi_1
X_0537_ VGND VPWR net25 daisychain\[17\] _0314_ net42 sg13g2_a21oi_1
XFILLER_26_203 VPWR VGND sg13g2_decap_8
XFILLER_39_597 VPWR VGND sg13g2_decap_8
XFILLER_42_707 VPWR VGND sg13g2_decap_4
XFILLER_42_718 VPWR VGND sg13g2_decap_8
X_0468_ _0194_ net75 _0261_ _0262_ VPWR VGND sg13g2_a21o_1
XFILLER_22_420 VPWR VGND sg13g2_decap_8
XFILLER_22_497 VPWR VGND sg13g2_decap_8
XFILLER_34_280 VPWR VGND sg13g2_decap_8
XFILLER_2_803 VPWR VGND sg13g2_fill_2
Xclkbuf_5_13__f_clk clknet_5_13__leaf_clk clknet_4_6_0_clk VPWR VGND sg13g2_buf_16
XFILLER_18_715 VPWR VGND sg13g2_decap_8
XFILLER_1_357 VPWR VGND sg13g2_decap_8
XFILLER_17_225 VPWR VGND sg13g2_decap_8
XFILLER_18_759 VPWR VGND sg13g2_decap_8
XFILLER_27_62 VPWR VGND sg13g2_decap_8
XFILLER_32_228 VPWR VGND sg13g2_decap_8
XFILLER_45_567 VPWR VGND sg13g2_decap_8
XFILLER_13_464 VPWR VGND sg13g2_decap_8
XFILLER_9_424 VPWR VGND sg13g2_decap_8
XFILLER_5_630 VPWR VGND sg13g2_decap_4
XFILLER_4_88 VPWR VGND sg13g2_decap_8
XFILLER_4_151 VPWR VGND sg13g2_decap_8
XFILLER_4_11 VPWR VGND sg13g2_decap_8
XFILLER_24_707 VPWR VGND sg13g2_fill_1
XFILLER_36_567 VPWR VGND sg13g2_decap_8
XFILLER_48_350 VPWR VGND sg13g2_decap_8
XFILLER_16_291 VPWR VGND sg13g2_decap_8
XFILLER_23_239 VPWR VGND sg13g2_decap_8
XFILLER_31_261 VPWR VGND sg13g2_decap_8
XFILLER_48_28 VPWR VGND sg13g2_decap_8
XFILLER_27_545 VPWR VGND sg13g2_decap_8
XFILLER_42_504 VPWR VGND sg13g2_decap_8
XFILLER_10_412 VPWR VGND sg13g2_decap_8
XFILLER_10_489 VPWR VGND sg13g2_decap_8
XFILLER_13_86 VPWR VGND sg13g2_decap_8
XFILLER_22_294 VPWR VGND sg13g2_decap_8
Xfanout32 _0192_ net32 VPWR VGND sg13g2_buf_1
Xfanout98 net1 net98 VPWR VGND sg13g2_buf_1
Xfanout87 net95 net87 VPWR VGND sg13g2_buf_1
Xfanout76 net77 net76 VPWR VGND sg13g2_buf_1
Xfanout65 net66 net65 VPWR VGND sg13g2_buf_1
Xfanout54 _0259_ net54 VPWR VGND sg13g2_buf_1
Xfanout43 net44 net43 VPWR VGND sg13g2_buf_1
XFILLER_6_449 VPWR VGND sg13g2_decap_8
XFILLER_1_154 VPWR VGND sg13g2_decap_8
XFILLER_2_600 VPWR VGND sg13g2_decap_4
XFILLER_2_611 VPWR VGND sg13g2_decap_4
XFILLER_2_622 VPWR VGND sg13g2_decap_4
XFILLER_18_567 VPWR VGND sg13g2_decap_8
XFILLER_49_158 VPWR VGND sg13g2_decap_8
XFILLER_13_261 VPWR VGND sg13g2_decap_8
XFILLER_14_773 VPWR VGND sg13g2_fill_2
XFILLER_33_515 VPWR VGND sg13g2_decap_8
XFILLER_41_581 VPWR VGND sg13g2_decap_8
XFILLER_45_364 VPWR VGND sg13g2_decap_8
X_0940_ net110 VGND VPWR _0100_ daisychain\[36\] clknet_5_25__leaf_clk sg13g2_dfrbpq_1
XFILLER_9_221 VPWR VGND sg13g2_decap_8
X_0871_ VPWR _0235_ daisychain\[42\] VGND sg13g2_inv_1
XFILLER_9_298 VPWR VGND sg13g2_decap_8
XFILLER_24_504 VPWR VGND sg13g2_decap_8
XFILLER_36_364 VPWR VGND sg13g2_decap_8
XFILLER_20_743 VPWR VGND sg13g2_fill_2
XFILLER_32_592 VPWR VGND sg13g2_decap_8
XFILLER_27_342 VPWR VGND sg13g2_decap_8
XFILLER_28_821 VPWR VGND sg13g2_fill_2
XFILLER_39_180 VPWR VGND sg13g2_decap_8
XFILLER_11_743 VPWR VGND sg13g2_fill_1
XFILLER_15_548 VPWR VGND sg13g2_decap_8
XFILLER_15_559 VPWR VGND sg13g2_fill_2
XFILLER_24_63 VPWR VGND sg13g2_decap_8
XFILLER_30_529 VPWR VGND sg13g2_decap_8
XFILLER_42_301 VPWR VGND sg13g2_decap_8
XFILLER_42_378 VPWR VGND sg13g2_decap_8
XFILLER_10_286 VPWR VGND sg13g2_decap_8
XFILLER_6_246 VPWR VGND sg13g2_decap_8
XFILLER_2_452 VPWR VGND sg13g2_decap_8
XFILLER_49_60 VPWR VGND sg13g2_decap_8
XFILLER_18_364 VPWR VGND sg13g2_decap_8
XFILLER_1_56 VPWR VGND sg13g2_decap_8
XFILLER_33_312 VPWR VGND sg13g2_decap_8
XFILLER_45_161 VPWR VGND sg13g2_decap_8
XFILLER_33_389 VPWR VGND sg13g2_decap_8
X_0854_ VPWR _0022_ state\[34\] VGND sg13g2_inv_1
X_0923_ net106 VGND VPWR _0083_ daisychain\[19\] clknet_5_17__leaf_clk sg13g2_dfrbpq_1
XFILLER_46_0 VPWR VGND sg13g2_decap_8
X_0785_ VPWR _0192_ net77 VGND sg13g2_inv_1
XFILLER_29_629 VPWR VGND sg13g2_decap_8
XFILLER_24_301 VPWR VGND sg13g2_decap_8
XFILLER_24_378 VPWR VGND sg13g2_decap_8
XFILLER_36_161 VPWR VGND sg13g2_decap_8
XFILLER_43_109 VPWR VGND sg13g2_decap_8
XFILLER_20_584 VPWR VGND sg13g2_decap_8
XFILLER_10_76 VPWR VGND sg13g2_decap_8
XFILLER_3_249 VPWR VGND sg13g2_decap_8
XFILLER_15_345 VPWR VGND sg13g2_decap_8
XFILLER_19_74 VPWR VGND sg13g2_decap_8
XFILLER_28_662 VPWR VGND sg13g2_decap_8
XFILLER_47_448 VPWR VGND sg13g2_decap_8
XFILLER_30_326 VPWR VGND sg13g2_decap_8
XFILLER_35_84 VPWR VGND sg13g2_decap_8
XFILLER_42_142 VPWR VGND sg13g2_decap_8
XFILLER_7_511 VPWR VGND sg13g2_decap_8
X_0570_ _0090_ _0337_ _0338_ net39 _0219_ VPWR VGND sg13g2_a22oi_1
XFILLER_7_599 VPWR VGND sg13g2_decap_8
XFILLER_18_4 VPWR VGND sg13g2_fill_1
XFILLER_38_448 VPWR VGND sg13g2_decap_8
XFILLER_18_161 VPWR VGND sg13g2_decap_8
XFILLER_19_662 VPWR VGND sg13g2_decap_8
XFILLER_21_337 VPWR VGND sg13g2_decap_8
XFILLER_33_186 VPWR VGND sg13g2_decap_8
X_1053_ daisychain\[61\] net20 VPWR VGND sg13g2_buf_1
X_0906_ net99 VGND VPWR _0066_ daisychain\[2\] clknet_5_2__leaf_clk sg13g2_dfrbpq_1
X_0837_ VPWR _0218_ daisychain\[25\] VGND sg13g2_inv_1
X_0768_ _0403_ VPWR _0176_ VGND net94 _0007_ sg13g2_o21ai_1
X_0699_ net76 VPWR _0435_ VGND net56 state\[59\] sg13g2_o21ai_1
XFILLER_16_109 VPWR VGND sg13g2_decap_8
XFILLER_25_621 VPWR VGND sg13g2_decap_8
XFILLER_29_426 VPWR VGND sg13g2_decap_8
XFILLER_44_429 VPWR VGND sg13g2_decap_8
XFILLER_24_175 VPWR VGND sg13g2_decap_8
XFILLER_25_698 VPWR VGND sg13g2_decap_8
XFILLER_40_613 VPWR VGND sg13g2_fill_1
XFILLER_20_381 VPWR VGND sg13g2_decap_8
XFILLER_21_64 VPWR VGND sg13g2_decap_8
XFILLER_4_536 VPWR VGND sg13g2_decap_8
XFILLER_47_245 VPWR VGND sg13g2_decap_8
XFILLER_15_142 VPWR VGND sg13g2_decap_8
XFILLER_16_676 VPWR VGND sg13g2_fill_1
XFILLER_16_687 VPWR VGND sg13g2_decap_8
XFILLER_30_123 VPWR VGND sg13g2_decap_8
XFILLER_31_646 VPWR VGND sg13g2_decap_8
XFILLER_7_77 VPWR VGND sg13g2_decap_8
X_0622_ _0103_ _0376_ _0377_ net52 _0232_ VPWR VGND sg13g2_a22oi_1
X_0553_ VGND VPWR net26 daisychain\[21\] _0326_ net41 sg13g2_a21oi_1
X_0484_ _0198_ net57 _0273_ _0274_ VPWR VGND sg13g2_a21o_1
XFILLER_7_385 VPWR VGND sg13g2_decap_8
XFILLER_38_245 VPWR VGND sg13g2_decap_8
XFILLER_21_134 VPWR VGND sg13g2_decap_8
XFILLER_22_602 VPWR VGND sg13g2_decap_8
XFILLER_22_679 VPWR VGND sg13g2_decap_8
XFILLER_34_462 VPWR VGND sg13g2_decap_8
XFILLER_30_690 VPWR VGND sg13g2_decap_8
XFILLER_1_539 VPWR VGND sg13g2_decap_8
XFILLER_29_223 VPWR VGND sg13g2_decap_8
XFILLER_16_53 VPWR VGND sg13g2_decap_8
XFILLER_17_407 VPWR VGND sg13g2_decap_8
XFILLER_25_495 VPWR VGND sg13g2_decap_8
XFILLER_44_226 VPWR VGND sg13g2_decap_8
XFILLER_12_167 VPWR VGND sg13g2_decap_8
XFILLER_32_74 VPWR VGND sg13g2_decap_8
XFILLER_40_421 VPWR VGND sg13g2_decap_8
XFILLER_40_498 VPWR VGND sg13g2_decap_8
XFILLER_9_628 VPWR VGND sg13g2_decap_8
XFILLER_4_333 VPWR VGND sg13g2_decap_8
XFILLER_48_532 VPWR VGND sg13g2_decap_8
XFILLER_16_473 VPWR VGND sg13g2_decap_8
XFILLER_31_443 VPWR VGND sg13g2_decap_8
XFILLER_35_259 VPWR VGND sg13g2_decap_8
XFILLER_43_292 VPWR VGND sg13g2_decap_8
XFILLER_7_182 VPWR VGND sg13g2_decap_8
XFILLER_39_510 VPWR VGND sg13g2_decap_8
X_0605_ VGND VPWR net27 daisychain\[34\] _0365_ net49 sg13g2_a21oi_1
X_0536_ _0211_ net63 _0312_ _0313_ VPWR VGND sg13g2_a21o_1
X_0467_ net78 VPWR _0261_ VGND net75 state\[1\] sg13g2_o21ai_1
XFILLER_26_259 VPWR VGND sg13g2_decap_8
XFILLER_27_727 VPWR VGND sg13g2_decap_8
XFILLER_39_576 VPWR VGND sg13g2_decap_8
X_1019_ net111 VGND VPWR _0179_ state\[51\] clknet_5_22__leaf_clk sg13g2_dfrbpq_1
XFILLER_22_476 VPWR VGND sg13g2_decap_8
XFILLER_1_336 VPWR VGND sg13g2_decap_8
XFILLER_17_204 VPWR VGND sg13g2_decap_8
XFILLER_45_546 VPWR VGND sg13g2_decap_8
XFILLER_13_443 VPWR VGND sg13g2_decap_8
XFILLER_32_207 VPWR VGND sg13g2_decap_8
XFILLER_33_719 VPWR VGND sg13g2_fill_1
XFILLER_9_403 VPWR VGND sg13g2_decap_8
XFILLER_40_295 VPWR VGND sg13g2_decap_8
XFILLER_43_95 VPWR VGND sg13g2_decap_8
XFILLER_5_675 VPWR VGND sg13g2_fill_1
XFILLER_4_130 VPWR VGND sg13g2_decap_8
XFILLER_4_67 VPWR VGND sg13g2_decap_8
XFILLER_23_218 VPWR VGND sg13g2_decap_8
XFILLER_36_546 VPWR VGND sg13g2_decap_8
XFILLER_16_270 VPWR VGND sg13g2_decap_8
XFILLER_31_240 VPWR VGND sg13g2_decap_8
XFILLER_27_524 VPWR VGND sg13g2_decap_8
XFILLER_39_362 VPWR VGND sg13g2_decap_8
X_0519_ net83 VPWR _0300_ VGND net62 state\[14\] sg13g2_o21ai_1
Xfanout33 _0192_ net33 VPWR VGND sg13g2_buf_1
Xfanout55 net5 net55 VPWR VGND sg13g2_buf_1
Xfanout44 net45 net44 VPWR VGND sg13g2_buf_1
XFILLER_10_468 VPWR VGND sg13g2_decap_8
XFILLER_13_65 VPWR VGND sg13g2_decap_8
XFILLER_22_273 VPWR VGND sg13g2_decap_8
Xfanout99 net117 net99 VPWR VGND sg13g2_buf_1
Xfanout88 net89 net88 VPWR VGND sg13g2_buf_1
Xfanout77 net96 net77 VPWR VGND sg13g2_buf_1
Xfanout66 net75 net66 VPWR VGND sg13g2_buf_1
XFILLER_6_428 VPWR VGND sg13g2_decap_8
XFILLER_1_133 VPWR VGND sg13g2_decap_8
XFILLER_2_689 VPWR VGND sg13g2_decap_8
XFILLER_49_137 VPWR VGND sg13g2_decap_8
XFILLER_18_546 VPWR VGND sg13g2_decap_8
XFILLER_38_84 VPWR VGND sg13g2_decap_8
XFILLER_45_343 VPWR VGND sg13g2_decap_8
XFILLER_13_240 VPWR VGND sg13g2_decap_8
XFILLER_41_560 VPWR VGND sg13g2_decap_8
X_0870_ VPWR _0001_ state\[42\] VGND sg13g2_inv_1
XFILLER_9_277 VPWR VGND sg13g2_decap_8
XFILLER_9_200 VPWR VGND sg13g2_decap_8
XFILLER_5_494 VPWR VGND sg13g2_decap_8
XFILLER_36_343 VPWR VGND sg13g2_decap_8
XFILLER_32_571 VPWR VGND sg13g2_decap_8
X_0999_ net107 VGND VPWR _0159_ state\[31\] clknet_5_14__leaf_clk sg13g2_dfrbpq_1
XFILLER_15_527 VPWR VGND sg13g2_decap_8
XFILLER_27_321 VPWR VGND sg13g2_decap_8
XFILLER_23_582 VPWR VGND sg13g2_decap_8
XFILLER_27_398 VPWR VGND sg13g2_decap_8
XFILLER_30_508 VPWR VGND sg13g2_decap_8
XFILLER_42_357 VPWR VGND sg13g2_decap_8
XFILLER_7_715 VPWR VGND sg13g2_fill_2
XFILLER_10_265 VPWR VGND sg13g2_decap_8
XFILLER_2_431 VPWR VGND sg13g2_decap_8
XFILLER_40_85 VPWR VGND sg13g2_decap_8
XFILLER_6_225 VPWR VGND sg13g2_decap_8
XFILLER_19_822 VPWR VGND sg13g2_fill_1
XFILLER_1_35 VPWR VGND sg13g2_decap_8
XFILLER_18_343 VPWR VGND sg13g2_decap_8
XFILLER_21_519 VPWR VGND sg13g2_decap_8
XFILLER_33_368 VPWR VGND sg13g2_decap_8
XFILLER_45_140 VPWR VGND sg13g2_decap_8
XFILLER_46_652 VPWR VGND sg13g2_decap_4
X_0853_ VPWR _0226_ daisychain\[33\] VGND sg13g2_inv_1
X_0922_ net106 VGND VPWR _0082_ daisychain\[18\] clknet_5_15__leaf_clk sg13g2_dfrbpq_1
XFILLER_39_0 VPWR VGND sg13g2_decap_4
X_0784_ _0449_ VPWR _0191_ VGND net76 _0024_ sg13g2_o21ai_1
XFILLER_5_291 VPWR VGND sg13g2_decap_8
XFILLER_25_814 VPWR VGND sg13g2_decap_8
XFILLER_29_608 VPWR VGND sg13g2_decap_8
XFILLER_36_140 VPWR VGND sg13g2_decap_8
Xinput1 rst_n net1 VPWR VGND sg13g2_buf_1
XFILLER_24_357 VPWR VGND sg13g2_decap_8
XFILLER_10_55 VPWR VGND sg13g2_decap_8
XFILLER_20_563 VPWR VGND sg13g2_decap_8
XFILLER_3_228 VPWR VGND sg13g2_decap_8
XFILLER_19_53 VPWR VGND sg13g2_decap_8
XFILLER_47_427 VPWR VGND sg13g2_decap_8
XFILLER_15_324 VPWR VGND sg13g2_decap_8
XFILLER_27_195 VPWR VGND sg13g2_decap_8
XFILLER_28_641 VPWR VGND sg13g2_decap_8
XFILLER_35_63 VPWR VGND sg13g2_decap_8
XFILLER_42_121 VPWR VGND sg13g2_decap_8
XFILLER_11_585 VPWR VGND sg13g2_decap_8
XFILLER_30_305 VPWR VGND sg13g2_decap_8
XFILLER_18_140 VPWR VGND sg13g2_decap_8
XFILLER_19_641 VPWR VGND sg13g2_decap_8
XFILLER_25_6 VPWR VGND sg13g2_fill_1
XFILLER_38_427 VPWR VGND sg13g2_decap_8
X_1052_ daisychain\[60\] net19 VPWR VGND sg13g2_buf_1
XFILLER_21_316 VPWR VGND sg13g2_decap_8
XFILLER_33_165 VPWR VGND sg13g2_decap_8
XFILLER_34_644 VPWR VGND sg13g2_decap_8
X_0905_ net99 VGND VPWR _0065_ daisychain\[1\] clknet_5_2__leaf_clk sg13g2_dfrbpq_1
X_0836_ VPWR _0049_ state\[25\] VGND sg13g2_inv_1
X_0767_ _0400_ VPWR _0175_ VGND net94 _0006_ sg13g2_o21ai_1
XFILLER_29_405 VPWR VGND sg13g2_decap_8
X_0698_ _0122_ _0433_ _0434_ net35 _0251_ VPWR VGND sg13g2_a22oi_1
XFILLER_13_817 VPWR VGND sg13g2_fill_2
XFILLER_25_600 VPWR VGND sg13g2_decap_8
XFILLER_25_677 VPWR VGND sg13g2_decap_8
XFILLER_40_603 VPWR VGND sg13g2_fill_2
XFILLER_44_408 VPWR VGND sg13g2_decap_8
XFILLER_12_349 VPWR VGND sg13g2_decap_8
XFILLER_20_360 VPWR VGND sg13g2_decap_8
XFILLER_24_154 VPWR VGND sg13g2_decap_8
XFILLER_21_43 VPWR VGND sg13g2_decap_8
XFILLER_4_515 VPWR VGND sg13g2_decap_8
XFILLER_0_776 VPWR VGND sg13g2_decap_4
XFILLER_47_224 VPWR VGND sg13g2_decap_8
XFILLER_15_121 VPWR VGND sg13g2_decap_8
XFILLER_15_198 VPWR VGND sg13g2_decap_8
XFILLER_30_102 VPWR VGND sg13g2_decap_8
XFILLER_31_625 VPWR VGND sg13g2_decap_8
XFILLER_46_84 VPWR VGND sg13g2_decap_8
Xclkbuf_5_0__f_clk clknet_5_0__leaf_clk clknet_4_0_0_clk VPWR VGND sg13g2_buf_16
XFILLER_11_382 VPWR VGND sg13g2_decap_8
XFILLER_30_179 VPWR VGND sg13g2_decap_8
X_0621_ VGND VPWR net29 daisychain\[38\] _0377_ net52 sg13g2_a21oi_1
XFILLER_7_56 VPWR VGND sg13g2_decap_8
XFILLER_7_364 VPWR VGND sg13g2_decap_8
XFILLER_30_4 VPWR VGND sg13g2_decap_4
XFILLER_39_703 VPWR VGND sg13g2_fill_1
XFILLER_3_592 VPWR VGND sg13g2_fill_2
X_0552_ _0215_ net65 _0324_ _0325_ VPWR VGND sg13g2_a21o_1
X_0483_ net79 VPWR _0273_ VGND net57 state\[5\] sg13g2_o21ai_1
XFILLER_34_441 VPWR VGND sg13g2_decap_8
XFILLER_38_224 VPWR VGND sg13g2_decap_8
XFILLER_21_113 VPWR VGND sg13g2_decap_8
XFILLER_22_658 VPWR VGND sg13g2_decap_8
XFILLER_1_518 VPWR VGND sg13g2_decap_8
X_0819_ VPWR _0209_ daisychain\[16\] VGND sg13g2_inv_1
XFILLER_29_202 VPWR VGND sg13g2_decap_8
XFILLER_29_279 VPWR VGND sg13g2_decap_8
XFILLER_44_205 VPWR VGND sg13g2_decap_8
XFILLER_25_474 VPWR VGND sg13g2_decap_8
XFILLER_40_400 VPWR VGND sg13g2_decap_8
XFILLER_12_146 VPWR VGND sg13g2_decap_8
XFILLER_21_680 VPWR VGND sg13g2_decap_8
XFILLER_32_53 VPWR VGND sg13g2_decap_8
XFILLER_40_477 VPWR VGND sg13g2_decap_8
XFILLER_8_139 VPWR VGND sg13g2_decap_8
XFILLER_4_312 VPWR VGND sg13g2_decap_8
XFILLER_4_389 VPWR VGND sg13g2_decap_8
XFILLER_48_511 VPWR VGND sg13g2_decap_8
XFILLER_0_595 VPWR VGND sg13g2_fill_2
XFILLER_35_238 VPWR VGND sg13g2_decap_8
XFILLER_48_588 VPWR VGND sg13g2_decap_8
XFILLER_12_680 VPWR VGND sg13g2_decap_8
XFILLER_16_452 VPWR VGND sg13g2_decap_8
XFILLER_31_422 VPWR VGND sg13g2_decap_8
XFILLER_31_499 VPWR VGND sg13g2_decap_8
XFILLER_43_271 VPWR VGND sg13g2_decap_8
X_0604_ _0228_ net67 _0363_ _0364_ VPWR VGND sg13g2_a21o_1
XFILLER_8_662 VPWR VGND sg13g2_fill_1
XFILLER_7_161 VPWR VGND sg13g2_decap_8
XFILLER_27_706 VPWR VGND sg13g2_decap_8
XFILLER_39_555 VPWR VGND sg13g2_decap_8
X_0535_ net84 VPWR _0312_ VGND net63 state\[18\] sg13g2_o21ai_1
X_0466_ _0064_ _0260_ _0258_ net36 _0193_ VPWR VGND sg13g2_a22oi_1
XFILLER_26_238 VPWR VGND sg13g2_decap_8
X_1018_ net114 VGND VPWR _0178_ state\[50\] clknet_5_22__leaf_clk sg13g2_dfrbpq_1
XFILLER_22_455 VPWR VGND sg13g2_decap_8
XFILLER_5_109 VPWR VGND sg13g2_decap_8
XFILLER_1_315 VPWR VGND sg13g2_decap_8
XFILLER_2_805 VPWR VGND sg13g2_fill_1
XFILLER_49_319 VPWR VGND sg13g2_decap_8
XFILLER_45_525 VPWR VGND sg13g2_decap_8
XFILLER_13_422 VPWR VGND sg13g2_decap_8
XFILLER_13_499 VPWR VGND sg13g2_decap_8
XFILLER_25_282 VPWR VGND sg13g2_decap_8
XFILLER_27_97 VPWR VGND sg13g2_decap_8
XFILLER_40_274 VPWR VGND sg13g2_decap_8
XFILLER_43_74 VPWR VGND sg13g2_decap_8
XFILLER_9_459 VPWR VGND sg13g2_decap_8
XFILLER_0_392 VPWR VGND sg13g2_decap_8
XFILLER_4_46 VPWR VGND sg13g2_decap_8
XFILLER_4_186 VPWR VGND sg13g2_decap_8
XFILLER_36_525 VPWR VGND sg13g2_decap_8
XFILLER_44_591 VPWR VGND sg13g2_fill_2
XFILLER_48_385 VPWR VGND sg13g2_decap_8
XFILLER_31_296 VPWR VGND sg13g2_decap_8
X_0518_ _0077_ _0298_ _0299_ net40 _0206_ VPWR VGND sg13g2_a22oi_1
XFILLER_27_503 VPWR VGND sg13g2_decap_8
XFILLER_39_341 VPWR VGND sg13g2_decap_8
XFILLER_14_219 VPWR VGND sg13g2_decap_8
XFILLER_22_252 VPWR VGND sg13g2_decap_8
XFILLER_23_764 VPWR VGND sg13g2_fill_2
XFILLER_42_539 VPWR VGND sg13g2_decap_8
Xfanout23 net24 net23 VPWR VGND sg13g2_buf_1
Xfanout34 _0259_ net34 VPWR VGND sg13g2_buf_1
Xfanout89 net90 net89 VPWR VGND sg13g2_buf_1
Xfanout78 net96 net78 VPWR VGND sg13g2_buf_1
Xfanout67 net68 net67 VPWR VGND sg13g2_buf_1
Xfanout56 net5 net56 VPWR VGND sg13g2_buf_1
Xfanout45 net46 net45 VPWR VGND sg13g2_buf_1
XFILLER_10_447 VPWR VGND sg13g2_decap_8
XFILLER_13_44 VPWR VGND sg13g2_decap_8
XFILLER_6_407 VPWR VGND sg13g2_decap_8
XFILLER_1_112 VPWR VGND sg13g2_decap_8
XFILLER_1_189 VPWR VGND sg13g2_decap_8
XFILLER_38_63 VPWR VGND sg13g2_decap_8
XFILLER_8_4 VPWR VGND sg13g2_decap_4
XFILLER_49_116 VPWR VGND sg13g2_decap_8
XFILLER_18_525 VPWR VGND sg13g2_decap_8
XFILLER_45_322 VPWR VGND sg13g2_decap_8
XFILLER_45_399 VPWR VGND sg13g2_decap_8
XFILLER_13_296 VPWR VGND sg13g2_decap_8
XFILLER_9_256 VPWR VGND sg13g2_decap_8
XFILLER_5_473 VPWR VGND sg13g2_decap_8
XFILLER_36_322 VPWR VGND sg13g2_decap_8
XFILLER_49_683 VPWR VGND sg13g2_decap_8
XFILLER_48_182 VPWR VGND sg13g2_decap_8
XFILLER_24_539 VPWR VGND sg13g2_decap_8
XFILLER_32_550 VPWR VGND sg13g2_decap_8
XFILLER_36_399 VPWR VGND sg13g2_decap_8
X_0998_ net107 VGND VPWR _0158_ state\[30\] clknet_5_14__leaf_clk sg13g2_dfrbpq_1
XFILLER_47_609 VPWR VGND sg13g2_decap_8
XFILLER_15_506 VPWR VGND sg13g2_decap_8
XFILLER_27_300 VPWR VGND sg13g2_decap_8
XFILLER_27_377 VPWR VGND sg13g2_decap_8
XFILLER_42_336 VPWR VGND sg13g2_decap_8
XFILLER_46_119 VPWR VGND sg13g2_decap_8
XFILLER_10_244 VPWR VGND sg13g2_decap_8
XFILLER_23_561 VPWR VGND sg13g2_decap_8
XFILLER_24_98 VPWR VGND sg13g2_decap_8
XFILLER_6_204 VPWR VGND sg13g2_decap_8
XFILLER_2_410 VPWR VGND sg13g2_decap_8
XFILLER_40_64 VPWR VGND sg13g2_decap_8
XFILLER_18_322 VPWR VGND sg13g2_decap_8
XFILLER_1_14 VPWR VGND sg13g2_decap_8
XFILLER_2_487 VPWR VGND sg13g2_decap_8
XFILLER_37_119 VPWR VGND sg13g2_decap_8
XFILLER_38_609 VPWR VGND sg13g2_fill_2
XFILLER_49_95 VPWR VGND sg13g2_decap_8
XFILLER_14_583 VPWR VGND sg13g2_decap_8
XFILLER_18_399 VPWR VGND sg13g2_decap_8
XFILLER_33_347 VPWR VGND sg13g2_decap_8
XFILLER_34_804 VPWR VGND sg13g2_decap_8
XFILLER_45_196 VPWR VGND sg13g2_decap_8
X_0921_ net106 VGND VPWR _0081_ daisychain\[17\] clknet_5_15__leaf_clk sg13g2_dfrbpq_1
XFILLER_41_391 VPWR VGND sg13g2_decap_8
X_0852_ VPWR _0011_ state\[33\] VGND sg13g2_inv_1
X_0783_ _0451_ VPWR _0190_ VGND _0444_ _0445_ sg13g2_o21ai_1
XFILLER_5_270 VPWR VGND sg13g2_decap_8
XFILLER_24_336 VPWR VGND sg13g2_decap_8
XFILLER_36_196 VPWR VGND sg13g2_decap_8
Xinput2 ui_in[0] net2 VPWR VGND sg13g2_buf_1
XFILLER_49_480 VPWR VGND sg13g2_decap_8
XFILLER_20_542 VPWR VGND sg13g2_decap_8
XFILLER_10_34 VPWR VGND sg13g2_decap_8
XFILLER_3_207 VPWR VGND sg13g2_decap_8
XFILLER_19_32 VPWR VGND sg13g2_decap_8
XFILLER_28_620 VPWR VGND sg13g2_decap_8
XFILLER_47_406 VPWR VGND sg13g2_decap_8
XFILLER_15_303 VPWR VGND sg13g2_decap_8
XFILLER_27_174 VPWR VGND sg13g2_decap_8
XFILLER_28_697 VPWR VGND sg13g2_decap_8
XFILLER_35_42 VPWR VGND sg13g2_decap_8
XFILLER_42_100 VPWR VGND sg13g2_decap_8
XFILLER_43_678 VPWR VGND sg13g2_fill_2
XFILLER_11_564 VPWR VGND sg13g2_decap_8
Xclkbuf_5_19__f_clk clknet_5_19__leaf_clk clknet_4_9_0_clk VPWR VGND sg13g2_buf_16
XFILLER_7_546 VPWR VGND sg13g2_decap_8
XFILLER_2_284 VPWR VGND sg13g2_decap_8
XFILLER_19_620 VPWR VGND sg13g2_decap_8
XFILLER_34_623 VPWR VGND sg13g2_decap_8
XFILLER_38_406 VPWR VGND sg13g2_decap_8
XFILLER_46_483 VPWR VGND sg13g2_decap_8
X_1051_ daisychain\[59\] net18 VPWR VGND sg13g2_buf_1
XFILLER_14_380 VPWR VGND sg13g2_decap_8
XFILLER_18_196 VPWR VGND sg13g2_decap_8
XFILLER_33_144 VPWR VGND sg13g2_decap_8
XFILLER_34_667 VPWR VGND sg13g2_decap_4
X_0904_ net99 VGND VPWR _0064_ daisychain\[0\] clknet_5_16__leaf_clk sg13g2_dfrbpq_1
X_0835_ VPWR _0217_ daisychain\[24\] VGND sg13g2_inv_1
X_0766_ _0397_ VPWR _0174_ VGND net92 _0005_ sg13g2_o21ai_1
X_0697_ VGND VPWR net33 daisychain\[57\] _0434_ net35 sg13g2_a21oi_1
XFILLER_24_133 VPWR VGND sg13g2_decap_8
XFILLER_25_656 VPWR VGND sg13g2_decap_8
XFILLER_37_483 VPWR VGND sg13g2_decap_8
XFILLER_12_328 VPWR VGND sg13g2_decap_8
XFILLER_21_99 VPWR VGND sg13g2_decap_8
XFILLER_0_788 VPWR VGND sg13g2_decap_4
XFILLER_0_799 VPWR VGND sg13g2_fill_1
XFILLER_15_100 VPWR VGND sg13g2_decap_8
XFILLER_16_634 VPWR VGND sg13g2_fill_2
XFILLER_28_494 VPWR VGND sg13g2_decap_8
XFILLER_46_63 VPWR VGND sg13g2_decap_8
XFILLER_47_203 VPWR VGND sg13g2_decap_8
XFILLER_15_177 VPWR VGND sg13g2_decap_8
XFILLER_30_158 VPWR VGND sg13g2_decap_8
XFILLER_31_604 VPWR VGND sg13g2_decap_8
XFILLER_43_453 VPWR VGND sg13g2_decap_4
XFILLER_43_497 VPWR VGND sg13g2_decap_8
XFILLER_11_361 VPWR VGND sg13g2_decap_8
X_0620_ _0232_ net72 _0375_ _0376_ VPWR VGND sg13g2_a21o_1
X_0551_ net86 VPWR _0324_ VGND net65 state\[22\] sg13g2_o21ai_1
XFILLER_7_35 VPWR VGND sg13g2_decap_8
XFILLER_7_343 VPWR VGND sg13g2_decap_8
XFILLER_23_4 VPWR VGND sg13g2_decap_8
XFILLER_38_203 VPWR VGND sg13g2_decap_8
X_0482_ _0068_ _0271_ _0272_ net38 _0197_ VPWR VGND sg13g2_a22oi_1
XFILLER_19_494 VPWR VGND sg13g2_decap_8
XFILLER_34_420 VPWR VGND sg13g2_decap_8
XFILLER_46_280 VPWR VGND sg13g2_decap_8
XFILLER_21_169 VPWR VGND sg13g2_decap_8
XFILLER_22_637 VPWR VGND sg13g2_decap_8
XFILLER_34_497 VPWR VGND sg13g2_decap_8
X_0818_ VPWR _0039_ state\[16\] VGND sg13g2_inv_1
X_0749_ _0346_ VPWR _0157_ VGND net87 _0053_ sg13g2_o21ai_1
XFILLER_29_258 VPWR VGND sg13g2_decap_8
XFILLER_12_125 VPWR VGND sg13g2_decap_8
XFILLER_13_604 VPWR VGND sg13g2_decap_8
XFILLER_13_615 VPWR VGND sg13g2_fill_2
XFILLER_16_88 VPWR VGND sg13g2_decap_8
XFILLER_25_453 VPWR VGND sg13g2_decap_8
XFILLER_37_280 VPWR VGND sg13g2_decap_8
XFILLER_40_456 VPWR VGND sg13g2_decap_8
XFILLER_8_118 VPWR VGND sg13g2_decap_8
XFILLER_32_32 VPWR VGND sg13g2_decap_8
XFILLER_0_574 VPWR VGND sg13g2_decap_8
XFILLER_4_368 VPWR VGND sg13g2_decap_8
XFILLER_16_431 VPWR VGND sg13g2_decap_8
XFILLER_28_291 VPWR VGND sg13g2_decap_8
XFILLER_29_770 VPWR VGND sg13g2_fill_1
XFILLER_31_401 VPWR VGND sg13g2_decap_8
XFILLER_35_217 VPWR VGND sg13g2_decap_8
XFILLER_43_250 VPWR VGND sg13g2_decap_8
XFILLER_48_567 VPWR VGND sg13g2_decap_8
XFILLER_31_478 VPWR VGND sg13g2_decap_8
XFILLER_7_140 VPWR VGND sg13g2_decap_8
X_0603_ net88 VPWR _0363_ VGND net67 state\[35\] sg13g2_o21ai_1
X_0534_ _0081_ _0310_ _0311_ net42 _0210_ VPWR VGND sg13g2_a22oi_1
XFILLER_26_217 VPWR VGND sg13g2_decap_8
X_0465_ VGND VPWR net32 net2 _0260_ net36 sg13g2_a21oi_1
XFILLER_19_291 VPWR VGND sg13g2_decap_8
XFILLER_22_434 VPWR VGND sg13g2_decap_8
XFILLER_34_294 VPWR VGND sg13g2_decap_8
XFILLER_41_209 VPWR VGND sg13g2_decap_8
X_1017_ net115 VGND VPWR _0177_ state\[49\] clknet_5_23__leaf_clk sg13g2_dfrbpq_1
XFILLER_13_401 VPWR VGND sg13g2_decap_8
XFILLER_17_239 VPWR VGND sg13g2_decap_8
XFILLER_18_729 VPWR VGND sg13g2_decap_4
XFILLER_27_21 VPWR VGND sg13g2_fill_2
XFILLER_27_76 VPWR VGND sg13g2_decap_8
XFILLER_45_504 VPWR VGND sg13g2_decap_8
XFILLER_13_478 VPWR VGND sg13g2_decap_8
XFILLER_25_261 VPWR VGND sg13g2_decap_8
XFILLER_40_253 VPWR VGND sg13g2_decap_8
XFILLER_41_732 VPWR VGND sg13g2_fill_2
XFILLER_43_53 VPWR VGND sg13g2_decap_8
XFILLER_9_438 VPWR VGND sg13g2_decap_8
XFILLER_4_25 VPWR VGND sg13g2_decap_8
XFILLER_4_165 VPWR VGND sg13g2_decap_8
XFILLER_0_371 VPWR VGND sg13g2_decap_8
XFILLER_36_504 VPWR VGND sg13g2_decap_8
XFILLER_48_364 VPWR VGND sg13g2_decap_8
XFILLER_32_765 VPWR VGND sg13g2_decap_8
XFILLER_44_570 VPWR VGND sg13g2_decap_8
XFILLER_31_275 VPWR VGND sg13g2_decap_8
XFILLER_8_482 VPWR VGND sg13g2_decap_8
X_0517_ VGND VPWR net26 daisychain\[12\] _0299_ net40 sg13g2_a21oi_1
XFILLER_27_559 VPWR VGND sg13g2_decap_8
XFILLER_39_320 VPWR VGND sg13g2_decap_8
XFILLER_42_518 VPWR VGND sg13g2_decap_8
XFILLER_10_426 VPWR VGND sg13g2_decap_8
XFILLER_13_23 VPWR VGND sg13g2_decap_8
XFILLER_22_231 VPWR VGND sg13g2_decap_8
XFILLER_23_732 VPWR VGND sg13g2_decap_4
XFILLER_35_581 VPWR VGND sg13g2_decap_8
Xfanout24 net31 net24 VPWR VGND sg13g2_buf_1
Xfanout79 net80 net79 VPWR VGND sg13g2_buf_1
Xfanout68 net69 net68 VPWR VGND sg13g2_buf_1
Xfanout57 net59 net57 VPWR VGND sg13g2_buf_1
Xfanout46 net54 net46 VPWR VGND sg13g2_buf_1
Xfanout35 _0259_ net35 VPWR VGND sg13g2_buf_1
XFILLER_18_504 VPWR VGND sg13g2_decap_8
XFILLER_1_168 VPWR VGND sg13g2_decap_8
XFILLER_38_42 VPWR VGND sg13g2_decap_8
XFILLER_45_301 VPWR VGND sg13g2_decap_8
XFILLER_26_581 VPWR VGND sg13g2_decap_8
XFILLER_33_529 VPWR VGND sg13g2_decap_8
XFILLER_45_378 VPWR VGND sg13g2_decap_8
XFILLER_13_275 VPWR VGND sg13g2_decap_8
XFILLER_41_595 VPWR VGND sg13g2_decap_4
XFILLER_9_235 VPWR VGND sg13g2_decap_8
Xdigitalen.g\[1\].u.inv1 VPWR digitalen.g\[1\].u.OUTN net6 VGND sg13g2_inv_1
XFILLER_5_452 VPWR VGND sg13g2_decap_8
XFILLER_24_518 VPWR VGND sg13g2_decap_8
XFILLER_36_301 VPWR VGND sg13g2_decap_8
XFILLER_36_378 VPWR VGND sg13g2_decap_8
XFILLER_49_662 VPWR VGND sg13g2_fill_1
XFILLER_48_161 VPWR VGND sg13g2_decap_8
X_0997_ net116 VGND VPWR _0157_ state\[29\] clknet_5_9__leaf_clk sg13g2_dfrbpq_1
XFILLER_23_540 VPWR VGND sg13g2_decap_8
XFILLER_27_356 VPWR VGND sg13g2_decap_8
XFILLER_39_194 VPWR VGND sg13g2_decap_8
XFILLER_42_315 VPWR VGND sg13g2_decap_8
XFILLER_10_223 VPWR VGND sg13g2_decap_8
XFILLER_24_77 VPWR VGND sg13g2_decap_8
XFILLER_40_43 VPWR VGND sg13g2_decap_8
XFILLER_2_466 VPWR VGND sg13g2_decap_8
XFILLER_18_301 VPWR VGND sg13g2_decap_8
XFILLER_19_813 VPWR VGND sg13g2_decap_8
XFILLER_49_74 VPWR VGND sg13g2_decap_8
XFILLER_14_562 VPWR VGND sg13g2_decap_8
XFILLER_18_378 VPWR VGND sg13g2_decap_8
XFILLER_33_326 VPWR VGND sg13g2_decap_8
XFILLER_41_370 VPWR VGND sg13g2_decap_8
XFILLER_45_175 VPWR VGND sg13g2_decap_8
X_0920_ net106 VGND VPWR _0080_ daisychain\[16\] clknet_5_13__leaf_clk sg13g2_dfrbpq_1
X_0851_ VPWR _0225_ daisychain\[32\] VGND sg13g2_inv_1
X_0782_ _0451_ net33 state\[62\] VPWR VGND sg13g2_nand2_1
XFILLER_28_109 VPWR VGND sg13g2_decap_8
XFILLER_24_315 VPWR VGND sg13g2_decap_8
XFILLER_36_175 VPWR VGND sg13g2_decap_8
Xinput3 ui_in[1] net3 VPWR VGND sg13g2_buf_1
XFILLER_20_521 VPWR VGND sg13g2_decap_8
XFILLER_20_598 VPWR VGND sg13g2_decap_8
XFILLER_10_13 VPWR VGND sg13g2_decap_8
XFILLER_19_109 VPWR VGND sg13g2_decap_8
XFILLER_19_88 VPWR VGND sg13g2_decap_8
XFILLER_27_153 VPWR VGND sg13g2_decap_8
XFILLER_28_676 VPWR VGND sg13g2_decap_8
XFILLER_15_359 VPWR VGND sg13g2_decap_8
XFILLER_31_819 VPWR VGND sg13g2_decap_4
XFILLER_35_21 VPWR VGND sg13g2_decap_8
XFILLER_35_98 VPWR VGND sg13g2_decap_8
XFILLER_42_156 VPWR VGND sg13g2_decap_8
XFILLER_11_543 VPWR VGND sg13g2_decap_8
XFILLER_7_525 VPWR VGND sg13g2_decap_8
XFILLER_2_263 VPWR VGND sg13g2_decap_8
XFILLER_18_175 VPWR VGND sg13g2_decap_8
XFILLER_19_676 VPWR VGND sg13g2_decap_4
XFILLER_33_123 VPWR VGND sg13g2_decap_8
XFILLER_34_602 VPWR VGND sg13g2_decap_8
XFILLER_46_462 VPWR VGND sg13g2_decap_8
X_1050_ daisychain\[58\] net17 VPWR VGND sg13g2_buf_1
X_0903_ VPWR _0251_ daisychain\[58\] VGND sg13g2_inv_1
X_0834_ VPWR _0048_ state\[24\] VGND sg13g2_inv_1
XFILLER_44_0 VPWR VGND sg13g2_decap_8
X_0765_ _0394_ VPWR _0173_ VGND net91 _0004_ sg13g2_o21ai_1
X_0696_ _0251_ net56 _0432_ _0433_ VPWR VGND sg13g2_a21o_1
XFILLER_6_580 VPWR VGND sg13g2_fill_2
Xclkbuf_5_25__f_clk clknet_5_25__leaf_clk clknet_4_12_0_clk VPWR VGND sg13g2_buf_16
XFILLER_12_307 VPWR VGND sg13g2_decap_8
XFILLER_13_819 VPWR VGND sg13g2_fill_1
XFILLER_24_112 VPWR VGND sg13g2_decap_8
XFILLER_24_189 VPWR VGND sg13g2_decap_8
XFILLER_25_635 VPWR VGND sg13g2_decap_8
XFILLER_37_462 VPWR VGND sg13g2_decap_8
XFILLER_40_605 VPWR VGND sg13g2_fill_1
XFILLER_20_395 VPWR VGND sg13g2_decap_8
XFILLER_21_78 VPWR VGND sg13g2_decap_8
XFILLER_16_613 VPWR VGND sg13g2_decap_8
XFILLER_28_473 VPWR VGND sg13g2_decap_8
XFILLER_43_432 VPWR VGND sg13g2_decap_8
XFILLER_46_42 VPWR VGND sg13g2_decap_8
XFILLER_47_259 VPWR VGND sg13g2_decap_8
XFILLER_11_340 VPWR VGND sg13g2_decap_8
XFILLER_15_156 VPWR VGND sg13g2_decap_8
XFILLER_30_137 VPWR VGND sg13g2_decap_8
XFILLER_7_322 VPWR VGND sg13g2_decap_8
XFILLER_7_14 VPWR VGND sg13g2_decap_8
XFILLER_3_550 VPWR VGND sg13g2_decap_8
XFILLER_3_572 VPWR VGND sg13g2_decap_8
X_0550_ _0085_ _0322_ _0323_ net43 _0214_ VPWR VGND sg13g2_a22oi_1
XFILLER_7_399 VPWR VGND sg13g2_decap_8
XFILLER_16_4 VPWR VGND sg13g2_decap_4
XFILLER_38_259 VPWR VGND sg13g2_decap_8
X_0481_ VGND VPWR net32 daisychain\[3\] _0272_ net36 sg13g2_a21oi_1
XFILLER_19_473 VPWR VGND sg13g2_decap_8
XFILLER_22_616 VPWR VGND sg13g2_decap_8
XFILLER_34_476 VPWR VGND sg13g2_decap_8
XFILLER_21_148 VPWR VGND sg13g2_decap_8
X_0817_ VPWR _0208_ daisychain\[15\] VGND sg13g2_inv_1
X_0748_ _0343_ VPWR _0156_ VGND net81 _0052_ sg13g2_o21ai_1
X_0679_ net88 VPWR _0420_ VGND net69 state\[54\] sg13g2_o21ai_1
XFILLER_29_237 VPWR VGND sg13g2_decap_8
XFILLER_45_708 VPWR VGND sg13g2_decap_4
XFILLER_12_104 VPWR VGND sg13g2_decap_8
XFILLER_16_67 VPWR VGND sg13g2_decap_8
XFILLER_32_11 VPWR VGND sg13g2_decap_8
XFILLER_40_435 VPWR VGND sg13g2_decap_8
XFILLER_20_192 VPWR VGND sg13g2_decap_8
XFILLER_32_88 VPWR VGND sg13g2_decap_8
XFILLER_4_347 VPWR VGND sg13g2_decap_8
XFILLER_0_553 VPWR VGND sg13g2_decap_8
XFILLER_48_546 VPWR VGND sg13g2_decap_8
XFILLER_16_410 VPWR VGND sg13g2_decap_8
XFILLER_16_487 VPWR VGND sg13g2_decap_4
XFILLER_28_270 VPWR VGND sg13g2_decap_8
XFILLER_31_457 VPWR VGND sg13g2_decap_8
X_0602_ _0098_ _0361_ _0362_ net49 _0227_ VPWR VGND sg13g2_a22oi_1
X_0533_ VGND VPWR net25 daisychain\[16\] _0311_ net42 sg13g2_a21oi_1
X_0464_ net76 net3 _0259_ VPWR VGND sg13g2_nor2_1
XFILLER_7_196 VPWR VGND sg13g2_decap_8
XFILLER_19_270 VPWR VGND sg13g2_decap_8
XFILLER_39_524 VPWR VGND sg13g2_decap_4
XFILLER_22_413 VPWR VGND sg13g2_decap_8
XFILLER_34_273 VPWR VGND sg13g2_decap_8
X_1016_ net115 VGND VPWR _0176_ state\[48\] clknet_5_23__leaf_clk sg13g2_dfrbpq_1
Xheichips25_pudding_120 VPWR VGND uio_oe[3] sg13g2_tiehi
XFILLER_8_90 VPWR VGND sg13g2_decap_8
XFILLER_18_708 VPWR VGND sg13g2_decap_8
XFILLER_17_218 VPWR VGND sg13g2_decap_8
XFILLER_25_240 VPWR VGND sg13g2_decap_8
XFILLER_27_55 VPWR VGND sg13g2_decap_8
XFILLER_13_457 VPWR VGND sg13g2_decap_8
XFILLER_40_232 VPWR VGND sg13g2_decap_8
XFILLER_9_417 VPWR VGND sg13g2_decap_8
XFILLER_5_623 VPWR VGND sg13g2_decap_8
XFILLER_5_634 VPWR VGND sg13g2_fill_2
XFILLER_4_144 VPWR VGND sg13g2_decap_8
XFILLER_0_350 VPWR VGND sg13g2_decap_8
XFILLER_48_343 VPWR VGND sg13g2_decap_8
XFILLER_16_284 VPWR VGND sg13g2_decap_8
XFILLER_31_254 VPWR VGND sg13g2_decap_8
XFILLER_44_593 VPWR VGND sg13g2_fill_1
XFILLER_8_461 VPWR VGND sg13g2_decap_8
X_0516_ _0206_ net61 _0297_ _0298_ VPWR VGND sg13g2_a21o_1
XFILLER_22_210 VPWR VGND sg13g2_decap_8
XFILLER_27_538 VPWR VGND sg13g2_decap_8
XFILLER_35_560 VPWR VGND sg13g2_decap_8
XFILLER_39_376 VPWR VGND sg13g2_decap_4
XFILLER_10_405 VPWR VGND sg13g2_decap_8
XFILLER_13_13 VPWR VGND sg13g2_fill_1
XFILLER_13_79 VPWR VGND sg13g2_decap_8
XFILLER_22_287 VPWR VGND sg13g2_decap_8
Xfanout25 net26 net25 VPWR VGND sg13g2_buf_1
Xfanout69 net74 net69 VPWR VGND sg13g2_buf_1
Xfanout58 net59 net58 VPWR VGND sg13g2_buf_1
Xfanout47 net48 net47 VPWR VGND sg13g2_buf_1
Xfanout36 net54 net36 VPWR VGND sg13g2_buf_1
XFILLER_1_147 VPWR VGND sg13g2_decap_8
XFILLER_2_615 VPWR VGND sg13g2_fill_2
XFILLER_2_626 VPWR VGND sg13g2_fill_1
XFILLER_38_98 VPWR VGND sg13g2_decap_8
XFILLER_13_254 VPWR VGND sg13g2_decap_8
XFILLER_14_766 VPWR VGND sg13g2_decap_8
XFILLER_14_799 VPWR VGND sg13g2_decap_4
XFILLER_26_560 VPWR VGND sg13g2_decap_8
XFILLER_33_508 VPWR VGND sg13g2_decap_8
XFILLER_41_574 VPWR VGND sg13g2_decap_8
XFILLER_45_357 VPWR VGND sg13g2_decap_8
XFILLER_9_214 VPWR VGND sg13g2_decap_8
Xdigitalen.g\[1\].u.inv2 VPWR digitalen.g\[1\].u.OUTP digitalen.g\[1\].u.OUTN VGND
+ sg13g2_inv_1
XFILLER_5_431 VPWR VGND sg13g2_decap_8
Xclkbuf_5_6__f_clk clknet_5_6__leaf_clk clknet_4_3_0_clk VPWR VGND sg13g2_buf_16
XFILLER_49_641 VPWR VGND sg13g2_decap_8
XFILLER_48_7 VPWR VGND sg13g2_decap_8
XFILLER_17_582 VPWR VGND sg13g2_decap_8
XFILLER_36_357 VPWR VGND sg13g2_decap_8
XFILLER_48_140 VPWR VGND sg13g2_decap_8
XFILLER_32_585 VPWR VGND sg13g2_decap_8
X_0996_ net103 VGND VPWR _0156_ state\[28\] clknet_5_8__leaf_clk sg13g2_dfrbpq_1
XFILLER_27_335 VPWR VGND sg13g2_decap_8
XFILLER_39_173 VPWR VGND sg13g2_decap_8
XFILLER_10_202 VPWR VGND sg13g2_decap_8
XFILLER_10_279 VPWR VGND sg13g2_decap_8
XFILLER_23_596 VPWR VGND sg13g2_decap_8
XFILLER_6_239 VPWR VGND sg13g2_decap_8
XFILLER_2_445 VPWR VGND sg13g2_decap_8
XFILLER_40_99 VPWR VGND sg13g2_decap_8
XFILLER_49_53 VPWR VGND sg13g2_decap_8
XFILLER_18_357 VPWR VGND sg13g2_decap_8
XFILLER_1_49 VPWR VGND sg13g2_decap_8
XFILLER_33_305 VPWR VGND sg13g2_decap_8
XFILLER_45_154 VPWR VGND sg13g2_decap_8
XFILLER_14_541 VPWR VGND sg13g2_decap_8
X_0850_ VPWR _0000_ state\[32\] VGND sg13g2_inv_1
X_0781_ _0442_ VPWR _0189_ VGND net77 _0021_ sg13g2_o21ai_1
Xinput4 ui_in[2] net4 VPWR VGND sg13g2_buf_1
XFILLER_20_500 VPWR VGND sg13g2_decap_8
XFILLER_36_154 VPWR VGND sg13g2_decap_8
XFILLER_20_577 VPWR VGND sg13g2_decap_8
XFILLER_32_382 VPWR VGND sg13g2_decap_8
X_0979_ net101 VGND VPWR _0139_ state\[11\] clknet_5_6__leaf_clk sg13g2_dfrbpq_1
XFILLER_10_69 VPWR VGND sg13g2_decap_8
XFILLER_19_67 VPWR VGND sg13g2_decap_8
XFILLER_27_132 VPWR VGND sg13g2_decap_8
XFILLER_28_655 VPWR VGND sg13g2_decap_8
XFILLER_11_522 VPWR VGND sg13g2_decap_8
XFILLER_15_338 VPWR VGND sg13g2_decap_8
XFILLER_23_393 VPWR VGND sg13g2_decap_8
XFILLER_30_319 VPWR VGND sg13g2_decap_8
XFILLER_35_77 VPWR VGND sg13g2_decap_8
XFILLER_42_135 VPWR VGND sg13g2_decap_8
XFILLER_7_504 VPWR VGND sg13g2_decap_8
XFILLER_11_599 VPWR VGND sg13g2_decap_8
XFILLER_2_242 VPWR VGND sg13g2_decap_8
XFILLER_3_776 VPWR VGND sg13g2_decap_4
XFILLER_18_154 VPWR VGND sg13g2_decap_8
XFILLER_19_655 VPWR VGND sg13g2_decap_8
XFILLER_33_102 VPWR VGND sg13g2_decap_8
XFILLER_33_179 VPWR VGND sg13g2_decap_8
XFILLER_34_658 VPWR VGND sg13g2_decap_4
XFILLER_46_441 VPWR VGND sg13g2_decap_8
X_0902_ VPWR _0018_ state\[58\] VGND sg13g2_inv_1
X_0833_ VPWR _0216_ daisychain\[23\] VGND sg13g2_inv_1
XFILLER_37_0 VPWR VGND sg13g2_decap_8
X_0764_ _0391_ VPWR _0172_ VGND net91 _0003_ sg13g2_o21ai_1
X_0695_ net76 VPWR _0432_ VGND net56 state\[58\] sg13g2_o21ai_1
XFILLER_25_614 VPWR VGND sg13g2_decap_8
XFILLER_29_419 VPWR VGND sg13g2_decap_8
XFILLER_2_81 VPWR VGND sg13g2_decap_8
XFILLER_37_441 VPWR VGND sg13g2_decap_8
XFILLER_21_820 VPWR VGND sg13g2_fill_2
XFILLER_24_168 VPWR VGND sg13g2_decap_8
XFILLER_20_374 VPWR VGND sg13g2_decap_8
XFILLER_21_57 VPWR VGND sg13g2_decap_8
XFILLER_4_529 VPWR VGND sg13g2_decap_8
XFILLER_0_713 VPWR VGND sg13g2_fill_2
XFILLER_0_735 VPWR VGND sg13g2_decap_8
XFILLER_0_757 VPWR VGND sg13g2_decap_4
XFILLER_15_135 VPWR VGND sg13g2_decap_8
XFILLER_16_636 VPWR VGND sg13g2_fill_1
XFILLER_28_452 VPWR VGND sg13g2_decap_8
XFILLER_43_411 VPWR VGND sg13g2_decap_8
XFILLER_46_21 VPWR VGND sg13g2_decap_8
XFILLER_46_98 VPWR VGND sg13g2_decap_8
XFILLER_47_238 VPWR VGND sg13g2_decap_8
XFILLER_11_396 VPWR VGND sg13g2_decap_8
XFILLER_23_190 VPWR VGND sg13g2_decap_8
XFILLER_30_116 VPWR VGND sg13g2_decap_8
XFILLER_31_639 VPWR VGND sg13g2_decap_8
XFILLER_7_301 VPWR VGND sg13g2_decap_8
Xclkbuf_5_31__f_clk clknet_5_31__leaf_clk clknet_4_15_0_clk VPWR VGND sg13g2_buf_16
X_0480_ _0197_ net57 _0270_ _0271_ VPWR VGND sg13g2_a21o_1
XFILLER_7_378 VPWR VGND sg13g2_decap_8
XFILLER_19_452 VPWR VGND sg13g2_decap_8
XFILLER_38_238 VPWR VGND sg13g2_decap_8
XFILLER_21_127 VPWR VGND sg13g2_decap_8
XFILLER_34_455 VPWR VGND sg13g2_decap_8
XFILLER_30_683 VPWR VGND sg13g2_decap_8
X_0816_ VPWR _0038_ state\[15\] VGND sg13g2_inv_1
X_0747_ _0340_ VPWR _0155_ VGND net80 _0051_ sg13g2_o21ai_1
XFILLER_29_216 VPWR VGND sg13g2_decap_8
X_0678_ _0117_ _0418_ _0419_ net49 _0246_ VPWR VGND sg13g2_a22oi_1
XFILLER_16_13 VPWR VGND sg13g2_fill_1
XFILLER_44_219 VPWR VGND sg13g2_decap_8
XFILLER_20_171 VPWR VGND sg13g2_decap_8
XFILLER_21_694 VPWR VGND sg13g2_decap_8
XFILLER_25_488 VPWR VGND sg13g2_decap_8
XFILLER_32_67 VPWR VGND sg13g2_decap_8
XFILLER_40_414 VPWR VGND sg13g2_decap_8
XFILLER_4_326 VPWR VGND sg13g2_decap_8
XFILLER_0_532 VPWR VGND sg13g2_decap_8
XFILLER_48_525 VPWR VGND sg13g2_decap_8
XFILLER_16_466 VPWR VGND sg13g2_decap_8
XFILLER_31_436 VPWR VGND sg13g2_decap_8
XFILLER_43_285 VPWR VGND sg13g2_decap_8
XFILLER_11_193 VPWR VGND sg13g2_decap_8
XFILLER_12_694 VPWR VGND sg13g2_fill_2
X_0601_ VGND VPWR net27 daisychain\[33\] _0362_ net49 sg13g2_a21oi_1
XFILLER_7_175 VPWR VGND sg13g2_decap_8
XFILLER_39_503 VPWR VGND sg13g2_decap_8
X_0532_ _0210_ net63 _0309_ _0310_ VPWR VGND sg13g2_a21o_1
X_0463_ net57 _0193_ _0257_ _0258_ VPWR VGND sg13g2_a21o_1
XFILLER_34_252 VPWR VGND sg13g2_decap_8
XFILLER_39_569 VPWR VGND sg13g2_decap_8
X_1015_ net114 VGND VPWR _0175_ state\[47\] clknet_5_21__leaf_clk sg13g2_dfrbpq_1
Xheichips25_pudding_121 VPWR VGND uio_oe[4] sg13g2_tiehi
XFILLER_22_469 VPWR VGND sg13g2_decap_8
XFILLER_30_480 VPWR VGND sg13g2_decap_8
XFILLER_1_329 VPWR VGND sg13g2_decap_8
XFILLER_2_819 VPWR VGND sg13g2_fill_1
XFILLER_13_436 VPWR VGND sg13g2_decap_8
XFILLER_25_296 VPWR VGND sg13g2_decap_8
XFILLER_26_742 VPWR VGND sg13g2_fill_1
XFILLER_40_211 VPWR VGND sg13g2_decap_8
XFILLER_45_539 VPWR VGND sg13g2_decap_8
XFILLER_21_491 VPWR VGND sg13g2_decap_8
XFILLER_40_288 VPWR VGND sg13g2_decap_8
XFILLER_43_88 VPWR VGND sg13g2_decap_8
XFILLER_4_123 VPWR VGND sg13g2_decap_8
XFILLER_49_812 VPWR VGND sg13g2_decap_8
XFILLER_29_580 VPWR VGND sg13g2_decap_8
XFILLER_36_539 VPWR VGND sg13g2_decap_8
XFILLER_48_399 VPWR VGND sg13g2_decap_8
XFILLER_48_322 VPWR VGND sg13g2_decap_8
XFILLER_16_263 VPWR VGND sg13g2_decap_8
XFILLER_31_233 VPWR VGND sg13g2_decap_8
XFILLER_32_701 VPWR VGND sg13g2_fill_1
XFILLER_8_440 VPWR VGND sg13g2_decap_8
XFILLER_27_517 VPWR VGND sg13g2_decap_8
XFILLER_39_355 VPWR VGND sg13g2_decap_8
X_0515_ net82 VPWR _0297_ VGND net61 state\[13\] sg13g2_o21ai_1
XFILLER_23_701 VPWR VGND sg13g2_decap_8
Xfanout26 net31 net26 VPWR VGND sg13g2_buf_1
Xfanout37 net38 net37 VPWR VGND sg13g2_buf_1
XFILLER_13_58 VPWR VGND sg13g2_decap_8
XFILLER_22_266 VPWR VGND sg13g2_decap_8
Xfanout59 net60 net59 VPWR VGND sg13g2_buf_1
Xfanout48 net49 net48 VPWR VGND sg13g2_buf_1
XFILLER_1_126 VPWR VGND sg13g2_decap_8
XFILLER_18_539 VPWR VGND sg13g2_decap_8
XFILLER_38_77 VPWR VGND sg13g2_decap_8
XFILLER_45_336 VPWR VGND sg13g2_decap_8
XFILLER_13_233 VPWR VGND sg13g2_decap_8
XFILLER_41_553 VPWR VGND sg13g2_decap_8
XFILLER_5_487 VPWR VGND sg13g2_decap_8
XFILLER_5_410 VPWR VGND sg13g2_decap_8
XFILLER_49_620 VPWR VGND sg13g2_decap_8
XFILLER_17_561 VPWR VGND sg13g2_decap_8
XFILLER_36_336 VPWR VGND sg13g2_decap_8
XFILLER_44_380 VPWR VGND sg13g2_decap_8
XFILLER_49_697 VPWR VGND sg13g2_fill_2
XFILLER_48_196 VPWR VGND sg13g2_decap_8
XFILLER_32_564 VPWR VGND sg13g2_decap_8
X_0995_ net102 VGND VPWR _0155_ state\[27\] clknet_5_11__leaf_clk sg13g2_dfrbpq_1
XFILLER_5_81 VPWR VGND sg13g2_decap_8
XFILLER_27_314 VPWR VGND sg13g2_decap_8
XFILLER_39_152 VPWR VGND sg13g2_decap_8
XFILLER_23_575 VPWR VGND sg13g2_decap_8
XFILLER_24_35 VPWR VGND sg13g2_fill_1
XFILLER_10_258 VPWR VGND sg13g2_decap_8
XFILLER_40_78 VPWR VGND sg13g2_decap_8
XFILLER_6_218 VPWR VGND sg13g2_decap_8
XFILLER_1_28 VPWR VGND sg13g2_decap_8
XFILLER_2_424 VPWR VGND sg13g2_decap_8
XFILLER_6_4 VPWR VGND sg13g2_decap_8
XFILLER_49_32 VPWR VGND sg13g2_decap_8
XFILLER_14_520 VPWR VGND sg13g2_decap_8
XFILLER_18_336 VPWR VGND sg13g2_decap_8
XFILLER_34_818 VPWR VGND sg13g2_decap_4
XFILLER_45_133 VPWR VGND sg13g2_decap_8
XFILLER_46_645 VPWR VGND sg13g2_decap_8
XFILLER_46_656 VPWR VGND sg13g2_fill_1
XFILLER_14_597 VPWR VGND sg13g2_decap_8
X_0780_ _0439_ VPWR _0188_ VGND net76 _0020_ sg13g2_o21ai_1
XFILLER_5_284 VPWR VGND sg13g2_decap_8
XFILLER_1_490 VPWR VGND sg13g2_decap_8
XFILLER_25_807 VPWR VGND sg13g2_decap_8
XFILLER_36_133 VPWR VGND sg13g2_decap_8
Xinput5 ui_in[3] net5 VPWR VGND sg13g2_buf_1
XFILLER_49_494 VPWR VGND sg13g2_decap_8
XFILLER_32_361 VPWR VGND sg13g2_decap_8
XFILLER_20_556 VPWR VGND sg13g2_decap_8
X_0978_ net104 VGND VPWR _0138_ state\[10\] clknet_5_7__leaf_clk sg13g2_dfrbpq_1
XFILLER_10_48 VPWR VGND sg13g2_decap_8
XFILLER_19_46 VPWR VGND sg13g2_decap_8
XFILLER_15_317 VPWR VGND sg13g2_decap_8
XFILLER_27_111 VPWR VGND sg13g2_decap_8
XFILLER_27_188 VPWR VGND sg13g2_decap_8
XFILLER_28_634 VPWR VGND sg13g2_decap_8
XFILLER_35_56 VPWR VGND sg13g2_decap_8
XFILLER_42_114 VPWR VGND sg13g2_decap_8
XFILLER_11_501 VPWR VGND sg13g2_decap_8
XFILLER_11_578 VPWR VGND sg13g2_fill_2
XFILLER_23_372 VPWR VGND sg13g2_decap_8
XFILLER_2_221 VPWR VGND sg13g2_decap_8
XFILLER_18_133 VPWR VGND sg13g2_decap_8
XFILLER_19_634 VPWR VGND sg13g2_decap_8
XFILLER_2_298 VPWR VGND sg13g2_decap_8
XFILLER_46_420 VPWR VGND sg13g2_decap_8
XFILLER_21_309 VPWR VGND sg13g2_decap_8
XFILLER_30_821 VPWR VGND sg13g2_fill_2
XFILLER_33_158 VPWR VGND sg13g2_decap_8
XFILLER_34_637 VPWR VGND sg13g2_decap_8
XFILLER_46_497 VPWR VGND sg13g2_decap_8
XFILLER_14_394 VPWR VGND sg13g2_decap_8
X_0901_ VPWR _0250_ daisychain\[57\] VGND sg13g2_inv_1
X_0832_ VPWR _0047_ state\[23\] VGND sg13g2_inv_1
X_0763_ _0388_ VPWR _0171_ VGND net91 _0002_ sg13g2_o21ai_1
X_0694_ _0121_ _0430_ _0431_ net34 _0250_ VPWR VGND sg13g2_a22oi_1
XFILLER_2_60 VPWR VGND sg13g2_decap_8
XFILLER_37_420 VPWR VGND sg13g2_decap_8
XFILLER_37_497 VPWR VGND sg13g2_decap_8
XFILLER_49_291 VPWR VGND sg13g2_decap_8
XFILLER_20_353 VPWR VGND sg13g2_decap_8
XFILLER_24_147 VPWR VGND sg13g2_decap_8
XFILLER_21_36 VPWR VGND sg13g2_decap_8
XFILLER_4_508 VPWR VGND sg13g2_decap_8
XFILLER_0_769 VPWR VGND sg13g2_decap_8
XFILLER_28_431 VPWR VGND sg13g2_decap_8
XFILLER_47_217 VPWR VGND sg13g2_decap_8
XFILLER_15_114 VPWR VGND sg13g2_decap_8
XFILLER_31_618 VPWR VGND sg13g2_decap_8
XFILLER_46_77 VPWR VGND sg13g2_decap_8
XFILLER_11_375 VPWR VGND sg13g2_decap_8
XFILLER_7_49 VPWR VGND sg13g2_decap_8
XFILLER_7_357 VPWR VGND sg13g2_decap_8
XFILLER_30_8 VPWR VGND sg13g2_fill_2
Xclkbuf_4_9_0_clk clknet_0_clk clknet_4_9_0_clk VPWR VGND sg13g2_buf_8
XFILLER_19_431 VPWR VGND sg13g2_decap_8
XFILLER_34_434 VPWR VGND sg13g2_decap_8
XFILLER_38_217 VPWR VGND sg13g2_decap_8
XFILLER_46_294 VPWR VGND sg13g2_decap_8
X_1031_ net98 VGND VPWR _0191_ state\[63\] clknet_5_27__leaf_clk sg13g2_dfrbpq_1
XFILLER_14_191 VPWR VGND sg13g2_decap_8
XFILLER_21_106 VPWR VGND sg13g2_decap_8
XFILLER_30_662 VPWR VGND sg13g2_decap_8
X_0815_ VPWR _0207_ daisychain\[14\] VGND sg13g2_inv_1
X_0746_ _0337_ VPWR _0154_ VGND net80 _0050_ sg13g2_o21ai_1
X_0677_ VGND VPWR net27 daisychain\[52\] _0419_ net47 sg13g2_a21oi_1
XFILLER_25_401 VPWR VGND sg13g2_decap_8
XFILLER_25_412 VPWR VGND sg13g2_fill_2
XFILLER_25_467 VPWR VGND sg13g2_decap_8
XFILLER_37_294 VPWR VGND sg13g2_decap_8
XFILLER_12_139 VPWR VGND sg13g2_decap_8
XFILLER_20_150 VPWR VGND sg13g2_decap_8
XFILLER_21_673 VPWR VGND sg13g2_decap_8
XFILLER_32_46 VPWR VGND sg13g2_decap_8
XFILLER_4_305 VPWR VGND sg13g2_decap_8
XFILLER_0_511 VPWR VGND sg13g2_decap_8
XFILLER_0_588 VPWR VGND sg13g2_decap_8
XFILLER_48_504 VPWR VGND sg13g2_decap_8
XFILLER_12_640 VPWR VGND sg13g2_fill_2
XFILLER_12_651 VPWR VGND sg13g2_fill_1
XFILLER_12_673 VPWR VGND sg13g2_decap_8
XFILLER_16_445 VPWR VGND sg13g2_decap_8
XFILLER_31_415 VPWR VGND sg13g2_decap_8
XFILLER_43_264 VPWR VGND sg13g2_decap_8
XFILLER_11_172 VPWR VGND sg13g2_decap_8
X_0600_ _0227_ net69 _0360_ _0361_ VPWR VGND sg13g2_a21o_1
X_0531_ net84 VPWR _0309_ VGND net63 state\[17\] sg13g2_o21ai_1
XFILLER_7_154 VPWR VGND sg13g2_decap_8
XFILLER_21_4 VPWR VGND sg13g2_fill_1
XFILLER_3_382 VPWR VGND sg13g2_decap_8
X_0462_ net79 VPWR _0257_ VGND state\[0\] net57 sg13g2_o21ai_1
XFILLER_34_231 VPWR VGND sg13g2_decap_8
XFILLER_35_743 VPWR VGND sg13g2_fill_1
XFILLER_47_581 VPWR VGND sg13g2_decap_8
X_1014_ net113 VGND VPWR _0174_ state\[46\] clknet_5_21__leaf_clk sg13g2_dfrbpq_1
Xheichips25_pudding_122 VPWR VGND uio_oe[5] sg13g2_tiehi
XFILLER_22_448 VPWR VGND sg13g2_decap_8
XFILLER_1_308 VPWR VGND sg13g2_decap_8
X_0729_ _0286_ VPWR _0137_ VGND net83 _0063_ sg13g2_o21ai_1
XFILLER_26_721 VPWR VGND sg13g2_decap_8
XFILLER_38_581 VPWR VGND sg13g2_decap_8
XFILLER_45_518 VPWR VGND sg13g2_decap_8
XFILLER_13_415 VPWR VGND sg13g2_decap_8
XFILLER_25_275 VPWR VGND sg13g2_decap_8
XFILLER_40_267 VPWR VGND sg13g2_decap_8
XFILLER_43_67 VPWR VGND sg13g2_decap_8
XFILLER_21_470 VPWR VGND sg13g2_decap_8
XFILLER_4_102 VPWR VGND sg13g2_decap_8
XFILLER_0_385 VPWR VGND sg13g2_decap_8
XFILLER_4_39 VPWR VGND sg13g2_decap_8
XFILLER_4_179 VPWR VGND sg13g2_decap_8
XFILLER_48_301 VPWR VGND sg13g2_decap_8
XFILLER_16_242 VPWR VGND sg13g2_decap_8
XFILLER_36_518 VPWR VGND sg13g2_decap_8
XFILLER_44_584 VPWR VGND sg13g2_decap_8
XFILLER_48_378 VPWR VGND sg13g2_decap_8
XFILLER_31_212 VPWR VGND sg13g2_decap_8
XFILLER_31_289 VPWR VGND sg13g2_decap_8
XFILLER_32_779 VPWR VGND sg13g2_fill_2
X_0514_ _0076_ _0295_ _0296_ net40 _0205_ VPWR VGND sg13g2_a22oi_1
XFILLER_8_496 VPWR VGND sg13g2_decap_8
XFILLER_39_334 VPWR VGND sg13g2_decap_8
XFILLER_22_245 VPWR VGND sg13g2_decap_8
XFILLER_35_595 VPWR VGND sg13g2_decap_8
Xfanout27 net30 net27 VPWR VGND sg13g2_buf_1
Xfanout49 net54 net49 VPWR VGND sg13g2_buf_1
Xfanout38 net39 net38 VPWR VGND sg13g2_buf_1
XFILLER_13_37 VPWR VGND sg13g2_decap_8
XFILLER_1_105 VPWR VGND sg13g2_decap_8
XFILLER_2_639 VPWR VGND sg13g2_fill_1
XFILLER_8_8 VPWR VGND sg13g2_fill_1
XFILLER_49_109 VPWR VGND sg13g2_decap_8
XFILLER_18_518 VPWR VGND sg13g2_decap_8
XFILLER_38_56 VPWR VGND sg13g2_decap_8
XFILLER_45_315 VPWR VGND sg13g2_decap_8
XFILLER_13_212 VPWR VGND sg13g2_decap_8
XFILLER_13_289 VPWR VGND sg13g2_decap_8
XFILLER_26_595 VPWR VGND sg13g2_decap_8
XFILLER_41_510 VPWR VGND sg13g2_decap_8
XFILLER_9_249 VPWR VGND sg13g2_decap_8
XFILLER_5_466 VPWR VGND sg13g2_decap_8
XFILLER_0_182 VPWR VGND sg13g2_decap_8
XFILLER_36_315 VPWR VGND sg13g2_decap_8
XFILLER_49_676 VPWR VGND sg13g2_decap_8
XFILLER_48_175 VPWR VGND sg13g2_decap_8
XFILLER_17_540 VPWR VGND sg13g2_decap_8
XFILLER_32_543 VPWR VGND sg13g2_decap_8
X_0994_ net102 VGND VPWR _0154_ state\[26\] clknet_5_8__leaf_clk sg13g2_dfrbpq_1
XFILLER_8_293 VPWR VGND sg13g2_decap_8
XFILLER_5_60 VPWR VGND sg13g2_decap_8
XFILLER_39_131 VPWR VGND sg13g2_decap_8
XFILLER_10_237 VPWR VGND sg13g2_decap_8
XFILLER_23_554 VPWR VGND sg13g2_decap_8
XFILLER_35_392 VPWR VGND sg13g2_decap_8
XFILLER_42_329 VPWR VGND sg13g2_decap_8
XFILLER_2_403 VPWR VGND sg13g2_decap_8
XFILLER_40_13 VPWR VGND sg13g2_decap_4
XFILLER_40_57 VPWR VGND sg13g2_decap_8
XFILLER_49_11 VPWR VGND sg13g2_decap_8
XFILLER_18_315 VPWR VGND sg13g2_decap_8
XFILLER_46_602 VPWR VGND sg13g2_decap_8
XFILLER_49_88 VPWR VGND sg13g2_decap_8
XFILLER_26_392 VPWR VGND sg13g2_decap_8
XFILLER_45_112 VPWR VGND sg13g2_decap_8
XFILLER_45_189 VPWR VGND sg13g2_decap_8
XFILLER_14_576 VPWR VGND sg13g2_decap_8
XFILLER_41_384 VPWR VGND sg13g2_decap_8
Xclkbuf_5_14__f_clk clknet_5_14__leaf_clk clknet_4_7_0_clk VPWR VGND sg13g2_buf_16
Xwires dac0/VcascP[0] dac0/VcascP[1] dac0/Iout wires/VDDA[0] wires/VDDA[1] dac0/VbiasP[1]
+ dac0/VbiasP[0] dac1/VcascP[0] dac1/VcascP[1] dac1/Iout wires/VDDA[2] wires/VDDA[3]
+ dac1/VbiasP[1] dac1/VbiasP[0] i_in i_out analog_wires
XFILLER_5_263 VPWR VGND sg13g2_decap_8
XFILLER_36_112 VPWR VGND sg13g2_decap_8
XFILLER_37_602 VPWR VGND sg13g2_decap_8
XFILLER_37_646 VPWR VGND sg13g2_fill_1
Xinput6 ui_in[4] net6 VPWR VGND sg13g2_buf_1
XFILLER_49_473 VPWR VGND sg13g2_decap_8
XFILLER_20_535 VPWR VGND sg13g2_decap_8
XFILLER_24_329 VPWR VGND sg13g2_decap_8
XFILLER_32_340 VPWR VGND sg13g2_decap_8
XFILLER_36_189 VPWR VGND sg13g2_decap_8
XFILLER_10_27 VPWR VGND sg13g2_decap_8
X_0977_ net104 VGND VPWR _0137_ state\[9\] clknet_5_7__leaf_clk sg13g2_dfrbpq_1
XFILLER_19_25 VPWR VGND sg13g2_decap_8
XFILLER_28_613 VPWR VGND sg13g2_decap_8
XFILLER_27_167 VPWR VGND sg13g2_decap_8
XFILLER_35_35 VPWR VGND sg13g2_decap_8
XFILLER_43_627 VPWR VGND sg13g2_decap_4
XFILLER_11_557 VPWR VGND sg13g2_decap_8
XFILLER_23_351 VPWR VGND sg13g2_decap_8
XFILLER_7_539 VPWR VGND sg13g2_decap_8
XFILLER_2_200 VPWR VGND sg13g2_decap_8
XFILLER_2_277 VPWR VGND sg13g2_decap_8
XFILLER_18_112 VPWR VGND sg13g2_decap_8
XFILLER_19_613 VPWR VGND sg13g2_decap_8
XFILLER_34_616 VPWR VGND sg13g2_decap_8
XFILLER_46_476 VPWR VGND sg13g2_decap_8
XFILLER_14_373 VPWR VGND sg13g2_decap_8
XFILLER_18_189 VPWR VGND sg13g2_decap_8
XFILLER_33_137 VPWR VGND sg13g2_decap_8
X_0900_ VPWR _0017_ state\[57\] VGND sg13g2_inv_1
X_0831_ VPWR _0215_ daisychain\[22\] VGND sg13g2_inv_1
X_0762_ _0385_ VPWR _0170_ VGND net92 _0001_ sg13g2_o21ai_1
X_0693_ VGND VPWR net33 daisychain\[56\] _0431_ net34 sg13g2_a21oi_1
XFILLER_24_126 VPWR VGND sg13g2_decap_8
XFILLER_25_649 VPWR VGND sg13g2_decap_8
XFILLER_37_476 VPWR VGND sg13g2_decap_8
XFILLER_49_270 VPWR VGND sg13g2_decap_8
XFILLER_20_332 VPWR VGND sg13g2_decap_8
XFILLER_21_822 VPWR VGND sg13g2_fill_1
XFILLER_0_715 VPWR VGND sg13g2_fill_1
XFILLER_28_410 VPWR VGND sg13g2_decap_8
XFILLER_46_56 VPWR VGND sg13g2_decap_8
XFILLER_16_627 VPWR VGND sg13g2_decap_8
XFILLER_24_693 VPWR VGND sg13g2_decap_8
XFILLER_28_487 VPWR VGND sg13g2_decap_8
XFILLER_43_446 VPWR VGND sg13g2_decap_8
XFILLER_43_457 VPWR VGND sg13g2_fill_1
XFILLER_11_354 VPWR VGND sg13g2_decap_8
XFILLER_7_336 VPWR VGND sg13g2_decap_8
XFILLER_7_28 VPWR VGND sg13g2_decap_8
XFILLER_11_81 VPWR VGND sg13g2_decap_8
XFILLER_3_586 VPWR VGND sg13g2_fill_1
XFILLER_3_597 VPWR VGND sg13g2_fill_1
XFILLER_19_410 VPWR VGND sg13g2_decap_8
XFILLER_19_487 VPWR VGND sg13g2_decap_8
XFILLER_34_413 VPWR VGND sg13g2_decap_8
XFILLER_46_273 VPWR VGND sg13g2_decap_8
X_1030_ net97 VGND VPWR _0190_ state\[62\] clknet_5_10__leaf_clk sg13g2_dfrbpq_1
XFILLER_14_170 VPWR VGND sg13g2_decap_8
XFILLER_15_671 VPWR VGND sg13g2_decap_4
XFILLER_30_641 VPWR VGND sg13g2_decap_8
XFILLER_42_490 VPWR VGND sg13g2_decap_8
X_0814_ VPWR _0037_ state\[14\] VGND sg13g2_inv_1
X_0745_ _0334_ VPWR _0153_ VGND net81 _0049_ sg13g2_o21ai_1
X_0676_ _0246_ net73 _0417_ _0418_ VPWR VGND sg13g2_a21o_1
XFILLER_12_118 VPWR VGND sg13g2_decap_8
XFILLER_25_446 VPWR VGND sg13g2_decap_8
XFILLER_37_273 VPWR VGND sg13g2_decap_8
XFILLER_40_449 VPWR VGND sg13g2_decap_8
XFILLER_21_652 VPWR VGND sg13g2_decap_8
XFILLER_32_25 VPWR VGND sg13g2_decap_8
XFILLER_0_567 VPWR VGND sg13g2_decap_8
XFILLER_16_424 VPWR VGND sg13g2_decap_8
XFILLER_28_284 VPWR VGND sg13g2_decap_8
XFILLER_43_243 VPWR VGND sg13g2_decap_8
XFILLER_11_151 VPWR VGND sg13g2_decap_8
XFILLER_24_490 VPWR VGND sg13g2_decap_8
XFILLER_22_91 VPWR VGND sg13g2_decap_8
XFILLER_3_361 VPWR VGND sg13g2_decap_8
X_0530_ _0080_ _0307_ _0308_ net42 _0209_ VPWR VGND sg13g2_a22oi_1
XFILLER_7_133 VPWR VGND sg13g2_decap_8
X_0461_ VPWR _0256_ daisychain\[63\] VGND sg13g2_inv_1
XFILLER_19_284 VPWR VGND sg13g2_decap_8
XFILLER_22_427 VPWR VGND sg13g2_decap_8
XFILLER_34_210 VPWR VGND sg13g2_decap_8
XFILLER_34_287 VPWR VGND sg13g2_decap_8
XFILLER_35_700 VPWR VGND sg13g2_fill_2
XFILLER_35_788 VPWR VGND sg13g2_fill_1
XFILLER_47_560 VPWR VGND sg13g2_decap_8
X_1013_ net115 VGND VPWR _0173_ state\[45\] clknet_5_19__leaf_clk sg13g2_dfrbpq_1
Xheichips25_pudding_123 VPWR VGND uio_oe[6] sg13g2_tiehi
X_0728_ _0283_ VPWR _0136_ VGND net81 _0062_ sg13g2_o21ai_1
X_0659_ net93 VPWR _0405_ VGND net72 state\[49\] sg13g2_o21ai_1
XFILLER_26_700 VPWR VGND sg13g2_decap_8
XFILLER_27_14 VPWR VGND sg13g2_decap_8
XFILLER_27_69 VPWR VGND sg13g2_decap_8
XFILLER_38_560 VPWR VGND sg13g2_decap_8
XFILLER_25_254 VPWR VGND sg13g2_decap_8
XFILLER_40_246 VPWR VGND sg13g2_decap_8
XFILLER_43_24 VPWR VGND sg13g2_fill_2
Xclkbuf_4_8_0_clk clknet_0_clk clknet_4_8_0_clk VPWR VGND sg13g2_buf_8
XFILLER_4_18 VPWR VGND sg13g2_decap_8
XFILLER_4_158 VPWR VGND sg13g2_decap_8
XFILLER_0_364 VPWR VGND sg13g2_decap_8
XFILLER_48_357 VPWR VGND sg13g2_decap_8
XFILLER_16_221 VPWR VGND sg13g2_decap_8
XFILLER_16_298 VPWR VGND sg13g2_decap_8
XFILLER_32_758 VPWR VGND sg13g2_decap_8
XFILLER_44_563 VPWR VGND sg13g2_decap_8
XFILLER_12_482 VPWR VGND sg13g2_decap_8
XFILLER_31_268 VPWR VGND sg13g2_decap_8
XFILLER_8_475 VPWR VGND sg13g2_decap_8
X_0513_ VGND VPWR net23 daisychain\[11\] _0296_ net37 sg13g2_a21oi_1
XFILLER_39_313 VPWR VGND sg13g2_decap_8
XFILLER_10_419 VPWR VGND sg13g2_decap_8
XFILLER_22_224 VPWR VGND sg13g2_decap_8
XFILLER_23_725 VPWR VGND sg13g2_decap_8
XFILLER_23_736 VPWR VGND sg13g2_fill_1
XFILLER_35_574 VPWR VGND sg13g2_decap_8
Xfanout28 net30 net28 VPWR VGND sg13g2_buf_1
Xfanout39 net46 net39 VPWR VGND sg13g2_buf_1
XFILLER_38_35 VPWR VGND sg13g2_decap_8
XFILLER_14_725 VPWR VGND sg13g2_fill_1
XFILLER_26_574 VPWR VGND sg13g2_decap_8
XFILLER_13_268 VPWR VGND sg13g2_decap_8
XFILLER_41_588 VPWR VGND sg13g2_decap_8
XFILLER_41_599 VPWR VGND sg13g2_fill_1
XFILLER_9_228 VPWR VGND sg13g2_decap_8
XFILLER_5_445 VPWR VGND sg13g2_decap_8
XFILLER_0_161 VPWR VGND sg13g2_decap_8
XFILLER_49_699 VPWR VGND sg13g2_fill_1
XFILLER_49_655 VPWR VGND sg13g2_decap_8
XFILLER_48_154 VPWR VGND sg13g2_decap_8
XFILLER_17_596 VPWR VGND sg13g2_decap_8
XFILLER_32_522 VPWR VGND sg13g2_decap_8
XFILLER_32_599 VPWR VGND sg13g2_decap_8
X_0993_ net104 VGND VPWR _0153_ state\[25\] clknet_5_12__leaf_clk sg13g2_dfrbpq_1
XFILLER_8_272 VPWR VGND sg13g2_decap_8
XFILLER_39_110 VPWR VGND sg13g2_decap_8
XFILLER_23_533 VPWR VGND sg13g2_decap_8
XFILLER_27_349 VPWR VGND sg13g2_decap_8
XFILLER_35_371 VPWR VGND sg13g2_decap_8
XFILLER_39_187 VPWR VGND sg13g2_decap_8
XFILLER_42_308 VPWR VGND sg13g2_decap_8
XFILLER_10_216 VPWR VGND sg13g2_decap_8
XFILLER_40_36 VPWR VGND sg13g2_decap_8
XFILLER_2_459 VPWR VGND sg13g2_decap_8
XFILLER_19_806 VPWR VGND sg13g2_decap_8
XFILLER_46_636 VPWR VGND sg13g2_fill_1
XFILLER_49_67 VPWR VGND sg13g2_decap_8
XFILLER_14_555 VPWR VGND sg13g2_decap_8
XFILLER_26_371 VPWR VGND sg13g2_decap_8
XFILLER_33_319 VPWR VGND sg13g2_decap_8
XFILLER_41_363 VPWR VGND sg13g2_decap_8
XFILLER_45_168 VPWR VGND sg13g2_decap_8
XFILLER_5_242 VPWR VGND sg13g2_decap_8
XFILLER_46_7 VPWR VGND sg13g2_decap_8
XFILLER_24_308 VPWR VGND sg13g2_decap_8
XFILLER_36_168 VPWR VGND sg13g2_decap_8
XFILLER_45_680 VPWR VGND sg13g2_fill_1
XFILLER_49_452 VPWR VGND sg13g2_decap_8
XFILLER_17_393 VPWR VGND sg13g2_decap_8
XFILLER_20_514 VPWR VGND sg13g2_decap_8
XFILLER_32_396 VPWR VGND sg13g2_decap_8
X_0976_ net101 VGND VPWR _0136_ state\[8\] clknet_5_1__leaf_clk sg13g2_dfrbpq_1
XFILLER_23_330 VPWR VGND sg13g2_decap_8
XFILLER_27_146 VPWR VGND sg13g2_decap_8
XFILLER_28_669 VPWR VGND sg13g2_decap_8
XFILLER_35_14 VPWR VGND sg13g2_decap_8
XFILLER_42_149 VPWR VGND sg13g2_decap_8
Xclkbuf_5_20__f_clk clknet_5_20__leaf_clk clknet_4_10_0_clk VPWR VGND sg13g2_buf_16
XFILLER_11_536 VPWR VGND sg13g2_decap_8
XFILLER_7_518 VPWR VGND sg13g2_decap_8
XFILLER_2_256 VPWR VGND sg13g2_decap_8
XFILLER_18_168 VPWR VGND sg13g2_decap_8
XFILLER_19_669 VPWR VGND sg13g2_decap_8
XFILLER_33_116 VPWR VGND sg13g2_decap_8
XFILLER_46_455 VPWR VGND sg13g2_decap_8
XFILLER_14_352 VPWR VGND sg13g2_decap_8
X_0830_ VPWR _0046_ state\[22\] VGND sg13g2_inv_1
X_0761_ _0382_ VPWR _0169_ VGND net92 _0031_ sg13g2_o21ai_1
X_0692_ _0250_ net55 _0429_ _0430_ VPWR VGND sg13g2_a21o_1
XFILLER_6_595 VPWR VGND sg13g2_fill_2
XFILLER_2_95 VPWR VGND sg13g2_decap_8
XFILLER_17_190 VPWR VGND sg13g2_decap_8
XFILLER_21_801 VPWR VGND sg13g2_fill_2
XFILLER_24_105 VPWR VGND sg13g2_decap_8
XFILLER_25_628 VPWR VGND sg13g2_decap_8
XFILLER_37_455 VPWR VGND sg13g2_decap_8
XFILLER_40_609 VPWR VGND sg13g2_decap_4
XFILLER_20_311 VPWR VGND sg13g2_decap_8
XFILLER_20_388 VPWR VGND sg13g2_decap_8
XFILLER_32_193 VPWR VGND sg13g2_decap_8
X_0959_ net99 VGND VPWR _0119_ daisychain\[55\] clknet_5_24__leaf_clk sg13g2_dfrbpq_1
XFILLER_16_606 VPWR VGND sg13g2_decap_8
XFILLER_28_466 VPWR VGND sg13g2_decap_8
XFILLER_43_425 VPWR VGND sg13g2_decap_8
XFILLER_46_35 VPWR VGND sg13g2_decap_8
XFILLER_11_333 VPWR VGND sg13g2_decap_8
XFILLER_15_149 VPWR VGND sg13g2_decap_8
XFILLER_24_672 VPWR VGND sg13g2_decap_8
XFILLER_7_315 VPWR VGND sg13g2_decap_8
XFILLER_11_60 VPWR VGND sg13g2_decap_8
XFILLER_3_543 VPWR VGND sg13g2_decap_8
XFILLER_16_8 VPWR VGND sg13g2_fill_1
XFILLER_19_466 VPWR VGND sg13g2_decap_8
XFILLER_22_609 VPWR VGND sg13g2_decap_8
XFILLER_34_469 VPWR VGND sg13g2_decap_8
XFILLER_46_252 VPWR VGND sg13g2_decap_8
XFILLER_30_620 VPWR VGND sg13g2_decap_8
XFILLER_30_697 VPWR VGND sg13g2_fill_2
X_0813_ VPWR _0206_ daisychain\[13\] VGND sg13g2_inv_1
XFILLER_35_0 VPWR VGND sg13g2_decap_8
X_0744_ _0331_ VPWR _0152_ VGND net83 _0048_ sg13g2_o21ai_1
X_0675_ net93 VPWR _0417_ VGND net73 state\[53\] sg13g2_o21ai_1
XFILLER_37_252 VPWR VGND sg13g2_decap_8
XFILLER_21_631 VPWR VGND sg13g2_decap_8
XFILLER_33_480 VPWR VGND sg13g2_decap_8
XFILLER_40_428 VPWR VGND sg13g2_decap_8
XFILLER_20_185 VPWR VGND sg13g2_decap_8
XFILLER_0_546 VPWR VGND sg13g2_decap_8
XFILLER_29_720 VPWR VGND sg13g2_fill_2
XFILLER_48_539 VPWR VGND sg13g2_decap_8
XFILLER_16_403 VPWR VGND sg13g2_decap_8
XFILLER_28_263 VPWR VGND sg13g2_decap_8
XFILLER_29_742 VPWR VGND sg13g2_fill_2
XFILLER_43_222 VPWR VGND sg13g2_decap_8
XFILLER_11_130 VPWR VGND sg13g2_decap_8
XFILLER_22_70 VPWR VGND sg13g2_decap_8
XFILLER_43_299 VPWR VGND sg13g2_decap_8
XFILLER_8_602 VPWR VGND sg13g2_fill_1
XFILLER_7_112 VPWR VGND sg13g2_decap_8
XFILLER_3_340 VPWR VGND sg13g2_decap_8
X_0460_ VPWR _0024_ state\[63\] VGND sg13g2_inv_1
XFILLER_7_189 VPWR VGND sg13g2_decap_8
XFILLER_19_263 VPWR VGND sg13g2_decap_8
XFILLER_39_517 VPWR VGND sg13g2_decap_8
XFILLER_39_528 VPWR VGND sg13g2_fill_2
X_1012_ net112 VGND VPWR _0172_ state\[44\] clknet_5_18__leaf_clk sg13g2_dfrbpq_1
XFILLER_22_406 VPWR VGND sg13g2_decap_8
XFILLER_34_266 VPWR VGND sg13g2_decap_8
Xheichips25_pudding_124 VPWR VGND uio_oe[7] sg13g2_tiehi
XFILLER_30_494 VPWR VGND sg13g2_decap_8
X_0727_ _0280_ VPWR _0135_ VGND net79 _0061_ sg13g2_o21ai_1
XFILLER_8_83 VPWR VGND sg13g2_decap_8
X_0658_ _0112_ _0403_ _0404_ net52 _0241_ VPWR VGND sg13g2_a22oi_1
X_0589_ VGND VPWR net25 daisychain\[30\] _0353_ net41 sg13g2_a21oi_1
XFILLER_25_233 VPWR VGND sg13g2_decap_8
XFILLER_43_14 VPWR VGND sg13g2_decap_4
XFILLER_40_225 VPWR VGND sg13g2_decap_8
XFILLER_41_737 VPWR VGND sg13g2_fill_1
XFILLER_1_822 VPWR VGND sg13g2_fill_1
XFILLER_4_137 VPWR VGND sg13g2_decap_8
XFILLER_0_343 VPWR VGND sg13g2_decap_8
XFILLER_48_336 VPWR VGND sg13g2_decap_8
XFILLER_16_200 VPWR VGND sg13g2_decap_8
XFILLER_16_277 VPWR VGND sg13g2_decap_8
XFILLER_17_92 VPWR VGND sg13g2_decap_8
XFILLER_29_594 VPWR VGND sg13g2_decap_8
XFILLER_31_247 VPWR VGND sg13g2_decap_8
XFILLER_44_542 VPWR VGND sg13g2_decap_8
XFILLER_12_461 VPWR VGND sg13g2_decap_8
XFILLER_8_454 VPWR VGND sg13g2_decap_8
X_0512_ _0205_ net61 _0294_ _0295_ VPWR VGND sg13g2_a21o_1
XFILLER_35_553 VPWR VGND sg13g2_decap_8
XFILLER_39_369 VPWR VGND sg13g2_decap_8
XFILLER_13_17 VPWR VGND sg13g2_fill_1
XFILLER_22_203 VPWR VGND sg13g2_decap_8
XFILLER_30_291 VPWR VGND sg13g2_decap_8
Xclkbuf_5_1__f_clk clknet_5_1__leaf_clk clknet_4_0_0_clk VPWR VGND sg13g2_buf_16
Xfanout29 net30 net29 VPWR VGND sg13g2_buf_1
XFILLER_38_14 VPWR VGND sg13g2_decap_4
XFILLER_13_247 VPWR VGND sg13g2_decap_8
XFILLER_14_715 VPWR VGND sg13g2_fill_1
XFILLER_26_553 VPWR VGND sg13g2_decap_8
XFILLER_38_380 VPWR VGND sg13g2_fill_1
XFILLER_41_567 VPWR VGND sg13g2_decap_8
XFILLER_9_207 VPWR VGND sg13g2_decap_8
XFILLER_5_424 VPWR VGND sg13g2_decap_8
XFILLER_0_140 VPWR VGND sg13g2_decap_8
XFILLER_49_634 VPWR VGND sg13g2_decap_8
XFILLER_29_391 VPWR VGND sg13g2_decap_8
XFILLER_49_667 VPWR VGND sg13g2_decap_4
XFILLER_48_133 VPWR VGND sg13g2_decap_8
XFILLER_13_770 VPWR VGND sg13g2_decap_4
XFILLER_13_781 VPWR VGND sg13g2_decap_4
XFILLER_17_575 VPWR VGND sg13g2_decap_8
XFILLER_32_501 VPWR VGND sg13g2_decap_8
XFILLER_32_578 VPWR VGND sg13g2_decap_8
XFILLER_44_394 VPWR VGND sg13g2_decap_8
X_0992_ net104 VGND VPWR _0152_ state\[24\] clknet_5_12__leaf_clk sg13g2_dfrbpq_1
XFILLER_8_251 VPWR VGND sg13g2_decap_8
XFILLER_39_166 VPWR VGND sg13g2_decap_8
Xclkbuf_4_7_0_clk clknet_0_clk clknet_4_7_0_clk VPWR VGND sg13g2_buf_8
XFILLER_5_95 VPWR VGND sg13g2_decap_8
XFILLER_23_512 VPWR VGND sg13g2_decap_8
XFILLER_27_328 VPWR VGND sg13g2_decap_8
XFILLER_35_350 VPWR VGND sg13g2_decap_8
XFILLER_23_589 VPWR VGND sg13g2_decap_8
XFILLER_2_438 VPWR VGND sg13g2_decap_8
XFILLER_49_46 VPWR VGND sg13g2_decap_8
XFILLER_45_147 VPWR VGND sg13g2_decap_8
XFILLER_14_534 VPWR VGND sg13g2_decap_8
XFILLER_26_350 VPWR VGND sg13g2_decap_8
XFILLER_41_342 VPWR VGND sg13g2_decap_8
XFILLER_14_93 VPWR VGND sg13g2_decap_8
XFILLER_30_81 VPWR VGND sg13g2_decap_8
XFILLER_5_298 VPWR VGND sg13g2_decap_8
XFILLER_5_221 VPWR VGND sg13g2_decap_8
XFILLER_49_431 VPWR VGND sg13g2_decap_8
XFILLER_17_372 VPWR VGND sg13g2_decap_8
XFILLER_36_147 VPWR VGND sg13g2_decap_8
XFILLER_44_191 VPWR VGND sg13g2_decap_8
XFILLER_32_375 VPWR VGND sg13g2_decap_8
X_0975_ net100 VGND VPWR _0135_ state\[7\] clknet_5_0__leaf_clk sg13g2_dfrbpq_1
XFILLER_9_571 VPWR VGND sg13g2_decap_8
XFILLER_27_125 VPWR VGND sg13g2_decap_8
XFILLER_28_648 VPWR VGND sg13g2_decap_8
XFILLER_11_515 VPWR VGND sg13g2_decap_8
XFILLER_23_386 VPWR VGND sg13g2_decap_8
XFILLER_24_821 VPWR VGND sg13g2_fill_2
XFILLER_42_128 VPWR VGND sg13g2_decap_8
XFILLER_2_235 VPWR VGND sg13g2_decap_8
XFILLER_3_769 VPWR VGND sg13g2_decap_8
XFILLER_4_4 VPWR VGND sg13g2_decap_8
XFILLER_14_331 VPWR VGND sg13g2_decap_8
XFILLER_18_147 VPWR VGND sg13g2_decap_8
XFILLER_19_648 VPWR VGND sg13g2_decap_8
XFILLER_27_692 VPWR VGND sg13g2_decap_8
XFILLER_46_434 VPWR VGND sg13g2_decap_8
XFILLER_41_161 VPWR VGND sg13g2_decap_8
XFILLER_42_662 VPWR VGND sg13g2_fill_2
XFILLER_42_695 VPWR VGND sg13g2_fill_1
X_0760_ _0379_ VPWR _0168_ VGND net93 _0030_ sg13g2_o21ai_1
XFILLER_10_592 VPWR VGND sg13g2_decap_8
XFILLER_41_91 VPWR VGND sg13g2_decap_8
X_0691_ net77 VPWR _0429_ VGND net55 state\[57\] sg13g2_o21ai_1
XFILLER_6_585 VPWR VGND sg13g2_decap_4
XFILLER_25_607 VPWR VGND sg13g2_decap_8
XFILLER_2_74 VPWR VGND sg13g2_decap_8
XFILLER_37_434 VPWR VGND sg13g2_decap_8
XFILLER_21_813 VPWR VGND sg13g2_decap_8
XFILLER_32_172 VPWR VGND sg13g2_decap_8
XFILLER_33_662 VPWR VGND sg13g2_fill_1
XFILLER_20_367 VPWR VGND sg13g2_decap_8
X_0889_ VPWR _0244_ daisychain\[51\] VGND sg13g2_inv_1
X_0958_ net110 VGND VPWR _0118_ daisychain\[54\] clknet_5_28__leaf_clk sg13g2_dfrbpq_1
XFILLER_0_706 VPWR VGND sg13g2_decap_8
XFILLER_0_728 VPWR VGND sg13g2_fill_1
XFILLER_15_128 VPWR VGND sg13g2_decap_8
XFILLER_28_445 VPWR VGND sg13g2_decap_8
XFILLER_43_404 VPWR VGND sg13g2_decap_8
XFILLER_46_14 VPWR VGND sg13g2_decap_8
XFILLER_11_312 VPWR VGND sg13g2_decap_8
XFILLER_11_389 VPWR VGND sg13g2_decap_8
XFILLER_23_183 VPWR VGND sg13g2_decap_8
XFILLER_24_651 VPWR VGND sg13g2_decap_8
XFILLER_30_109 VPWR VGND sg13g2_decap_8
XFILLER_3_522 VPWR VGND sg13g2_decap_8
XFILLER_19_445 VPWR VGND sg13g2_decap_8
XFILLER_46_231 VPWR VGND sg13g2_decap_8
XFILLER_34_448 VPWR VGND sg13g2_decap_8
XFILLER_36_91 VPWR VGND sg13g2_decap_8
XFILLER_30_676 VPWR VGND sg13g2_decap_8
X_0812_ VPWR _0036_ state\[13\] VGND sg13g2_inv_1
X_0743_ _0328_ VPWR _0151_ VGND net86 _0047_ sg13g2_o21ai_1
XFILLER_29_209 VPWR VGND sg13g2_decap_8
X_0674_ _0116_ _0415_ _0416_ net47 _0245_ VPWR VGND sg13g2_a22oi_1
XFILLER_6_393 VPWR VGND sg13g2_decap_8
XFILLER_37_231 VPWR VGND sg13g2_decap_8
XFILLER_20_164 VPWR VGND sg13g2_decap_8
XFILLER_21_610 VPWR VGND sg13g2_decap_8
XFILLER_21_687 VPWR VGND sg13g2_decap_8
XFILLER_40_407 VPWR VGND sg13g2_decap_8
XFILLER_4_319 VPWR VGND sg13g2_decap_8
XFILLER_0_525 VPWR VGND sg13g2_decap_8
XFILLER_48_518 VPWR VGND sg13g2_decap_8
XFILLER_16_459 VPWR VGND sg13g2_decap_8
XFILLER_28_242 VPWR VGND sg13g2_decap_8
XFILLER_31_429 VPWR VGND sg13g2_decap_8
XFILLER_43_201 VPWR VGND sg13g2_decap_8
XFILLER_43_278 VPWR VGND sg13g2_decap_8
XFILLER_11_186 VPWR VGND sg13g2_decap_8
XFILLER_12_687 VPWR VGND sg13g2_decap_4
XFILLER_7_168 VPWR VGND sg13g2_decap_8
XFILLER_3_396 VPWR VGND sg13g2_decap_8
XFILLER_19_242 VPWR VGND sg13g2_decap_8
XFILLER_47_595 VPWR VGND sg13g2_decap_8
X_1011_ net112 VGND VPWR _0171_ state\[43\] clknet_5_17__leaf_clk sg13g2_dfrbpq_1
XFILLER_15_492 VPWR VGND sg13g2_decap_8
XFILLER_30_473 VPWR VGND sg13g2_decap_8
XFILLER_34_245 VPWR VGND sg13g2_decap_8
X_0726_ _0277_ VPWR _0134_ VGND net79 _0060_ sg13g2_o21ai_1
XFILLER_8_62 VPWR VGND sg13g2_decap_8
XFILLER_6_190 VPWR VGND sg13g2_decap_8
X_0657_ VGND VPWR net29 daisychain\[47\] _0404_ net52 sg13g2_a21oi_1
X_0588_ _0224_ net65 _0351_ _0352_ VPWR VGND sg13g2_a21o_1
XFILLER_13_429 VPWR VGND sg13g2_decap_8
XFILLER_25_212 VPWR VGND sg13g2_decap_8
XFILLER_25_289 VPWR VGND sg13g2_decap_8
XFILLER_26_735 VPWR VGND sg13g2_decap_8
XFILLER_38_595 VPWR VGND sg13g2_decap_8
XFILLER_40_204 VPWR VGND sg13g2_decap_8
XFILLER_21_484 VPWR VGND sg13g2_decap_8
XFILLER_0_322 VPWR VGND sg13g2_decap_8
XFILLER_4_116 VPWR VGND sg13g2_decap_8
XFILLER_49_805 VPWR VGND sg13g2_decap_8
XFILLER_0_399 VPWR VGND sg13g2_decap_8
XFILLER_29_573 VPWR VGND sg13g2_decap_8
XFILLER_44_521 VPWR VGND sg13g2_decap_8
XFILLER_48_315 VPWR VGND sg13g2_decap_8
XFILLER_12_440 VPWR VGND sg13g2_decap_8
XFILLER_16_256 VPWR VGND sg13g2_decap_8
XFILLER_17_71 VPWR VGND sg13g2_decap_8
XFILLER_31_226 VPWR VGND sg13g2_decap_8
XFILLER_33_81 VPWR VGND sg13g2_decap_8
X_0511_ net82 VPWR _0294_ VGND net61 state\[12\] sg13g2_o21ai_1
XFILLER_8_433 VPWR VGND sg13g2_decap_8
XFILLER_39_348 VPWR VGND sg13g2_decap_8
XFILLER_3_193 VPWR VGND sg13g2_decap_8
XFILLER_35_532 VPWR VGND sg13g2_decap_8
XFILLER_47_392 VPWR VGND sg13g2_decap_8
XFILLER_22_259 VPWR VGND sg13g2_decap_8
XFILLER_30_270 VPWR VGND sg13g2_decap_8
XFILLER_1_119 VPWR VGND sg13g2_decap_8
X_0709_ VGND VPWR net33 daisychain\[60\] _0443_ net34 sg13g2_a21oi_1
XFILLER_26_532 VPWR VGND sg13g2_decap_8
XFILLER_45_329 VPWR VGND sg13g2_decap_8
XFILLER_13_226 VPWR VGND sg13g2_decap_8
XFILLER_14_705 VPWR VGND sg13g2_decap_8
XFILLER_14_738 VPWR VGND sg13g2_fill_1
XFILLER_41_546 VPWR VGND sg13g2_decap_8
XFILLER_21_281 VPWR VGND sg13g2_decap_8
XFILLER_5_403 VPWR VGND sg13g2_decap_8
XFILLER_0_196 VPWR VGND sg13g2_decap_8
XFILLER_49_613 VPWR VGND sg13g2_decap_8
XFILLER_48_112 VPWR VGND sg13g2_decap_8
XFILLER_17_554 VPWR VGND sg13g2_decap_8
XFILLER_28_81 VPWR VGND sg13g2_decap_8
XFILLER_29_370 VPWR VGND sg13g2_decap_8
XFILLER_36_329 VPWR VGND sg13g2_decap_8
XFILLER_37_819 VPWR VGND sg13g2_decap_4
XFILLER_44_373 VPWR VGND sg13g2_decap_8
XFILLER_48_189 VPWR VGND sg13g2_decap_8
XFILLER_32_557 VPWR VGND sg13g2_decap_8
X_0991_ net107 VGND VPWR _0151_ state\[23\] clknet_5_12__leaf_clk sg13g2_dfrbpq_1
XFILLER_8_230 VPWR VGND sg13g2_decap_8
XFILLER_5_74 VPWR VGND sg13g2_decap_8
XFILLER_4_480 VPWR VGND sg13g2_decap_8
XFILLER_27_307 VPWR VGND sg13g2_decap_8
XFILLER_39_145 VPWR VGND sg13g2_decap_8
XFILLER_23_568 VPWR VGND sg13g2_decap_8
XFILLER_24_28 VPWR VGND sg13g2_decap_8
XFILLER_31_590 VPWR VGND sg13g2_decap_8
XFILLER_2_417 VPWR VGND sg13g2_decap_8
XFILLER_49_25 VPWR VGND sg13g2_decap_8
XFILLER_14_513 VPWR VGND sg13g2_decap_8
XFILLER_18_329 VPWR VGND sg13g2_decap_8
XFILLER_45_126 VPWR VGND sg13g2_decap_8
XFILLER_46_616 VPWR VGND sg13g2_decap_8
XFILLER_14_72 VPWR VGND sg13g2_decap_8
XFILLER_41_321 VPWR VGND sg13g2_decap_8
XFILLER_41_398 VPWR VGND sg13g2_decap_8
XFILLER_30_60 VPWR VGND sg13g2_decap_8
XFILLER_5_277 VPWR VGND sg13g2_decap_8
XFILLER_5_200 VPWR VGND sg13g2_decap_8
XFILLER_1_483 VPWR VGND sg13g2_decap_8
XFILLER_36_126 VPWR VGND sg13g2_decap_8
XFILLER_37_616 VPWR VGND sg13g2_fill_2
XFILLER_49_487 VPWR VGND sg13g2_decap_8
XFILLER_49_410 VPWR VGND sg13g2_decap_8
XFILLER_17_351 VPWR VGND sg13g2_decap_8
XFILLER_32_354 VPWR VGND sg13g2_decap_8
XFILLER_33_822 VPWR VGND sg13g2_fill_1
XFILLER_44_170 VPWR VGND sg13g2_decap_8
XFILLER_45_693 VPWR VGND sg13g2_fill_1
XFILLER_13_590 VPWR VGND sg13g2_decap_8
XFILLER_20_549 VPWR VGND sg13g2_decap_8
X_0974_ net101 VGND VPWR _0134_ state\[6\] clknet_5_1__leaf_clk sg13g2_dfrbpq_1
XFILLER_9_550 VPWR VGND sg13g2_decap_8
XFILLER_19_39 VPWR VGND sg13g2_decap_8
XFILLER_27_104 VPWR VGND sg13g2_decap_8
XFILLER_28_627 VPWR VGND sg13g2_decap_8
XFILLER_35_49 VPWR VGND sg13g2_decap_8
XFILLER_42_107 VPWR VGND sg13g2_decap_8
XFILLER_23_365 VPWR VGND sg13g2_decap_8
XFILLER_2_214 VPWR VGND sg13g2_decap_8
XFILLER_19_627 VPWR VGND sg13g2_decap_8
XFILLER_46_413 VPWR VGND sg13g2_decap_8
XFILLER_14_310 VPWR VGND sg13g2_decap_8
XFILLER_15_811 VPWR VGND sg13g2_decap_8
XFILLER_15_822 VPWR VGND sg13g2_fill_1
XFILLER_18_126 VPWR VGND sg13g2_decap_8
XFILLER_27_671 VPWR VGND sg13g2_decap_8
XFILLER_30_803 VPWR VGND sg13g2_fill_1
XFILLER_30_814 VPWR VGND sg13g2_decap_8
XFILLER_41_140 VPWR VGND sg13g2_decap_8
XFILLER_14_387 VPWR VGND sg13g2_decap_8
XFILLER_25_93 VPWR VGND sg13g2_decap_8
XFILLER_41_195 VPWR VGND sg13g2_decap_8
XFILLER_41_70 VPWR VGND sg13g2_decap_8
Xclkbuf_4_6_0_clk clknet_0_clk clknet_4_6_0_clk VPWR VGND sg13g2_buf_8
X_0690_ _0120_ _0427_ _0428_ net48 _0249_ VPWR VGND sg13g2_a22oi_1
XFILLER_1_280 VPWR VGND sg13g2_decap_8
XFILLER_2_53 VPWR VGND sg13g2_decap_8
XFILLER_37_413 VPWR VGND sg13g2_decap_8
XFILLER_49_284 VPWR VGND sg13g2_decap_8
XFILLER_18_693 VPWR VGND sg13g2_fill_1
XFILLER_20_346 VPWR VGND sg13g2_decap_8
XFILLER_32_151 VPWR VGND sg13g2_decap_8
XFILLER_33_641 VPWR VGND sg13g2_decap_8
XFILLER_45_490 VPWR VGND sg13g2_decap_8
X_0888_ VPWR _0010_ state\[51\] VGND sg13g2_inv_1
X_0957_ net109 VGND VPWR _0117_ daisychain\[53\] clknet_5_31__leaf_clk sg13g2_dfrbpq_1
XFILLER_28_424 VPWR VGND sg13g2_decap_8
XFILLER_15_107 VPWR VGND sg13g2_decap_8
XFILLER_24_630 VPWR VGND sg13g2_decap_8
XFILLER_36_490 VPWR VGND sg13g2_decap_8
XFILLER_11_368 VPWR VGND sg13g2_decap_8
XFILLER_23_162 VPWR VGND sg13g2_decap_8
XFILLER_11_95 VPWR VGND sg13g2_decap_8
XFILLER_3_501 VPWR VGND sg13g2_decap_8
XFILLER_19_424 VPWR VGND sg13g2_decap_8
XFILLER_46_210 VPWR VGND sg13g2_decap_8
XFILLER_14_184 VPWR VGND sg13g2_decap_8
XFILLER_30_655 VPWR VGND sg13g2_decap_8
XFILLER_34_427 VPWR VGND sg13g2_decap_8
XFILLER_36_70 VPWR VGND sg13g2_decap_8
XFILLER_46_287 VPWR VGND sg13g2_decap_8
XFILLER_30_699 VPWR VGND sg13g2_fill_1
X_0811_ VPWR _0205_ daisychain\[12\] VGND sg13g2_inv_1
X_0742_ _0325_ VPWR _0150_ VGND net86 _0046_ sg13g2_o21ai_1
X_0673_ VGND VPWR net27 daisychain\[51\] _0416_ net47 sg13g2_a21oi_1
XFILLER_6_372 VPWR VGND sg13g2_decap_8
XFILLER_18_490 VPWR VGND sg13g2_decap_8
XFILLER_37_210 VPWR VGND sg13g2_decap_8
XFILLER_37_287 VPWR VGND sg13g2_decap_8
XFILLER_20_143 VPWR VGND sg13g2_decap_8
XFILLER_21_666 VPWR VGND sg13g2_decap_8
XFILLER_32_39 VPWR VGND sg13g2_decap_8
XFILLER_0_504 VPWR VGND sg13g2_decap_8
XFILLER_28_221 VPWR VGND sg13g2_decap_8
XFILLER_16_438 VPWR VGND sg13g2_decap_8
XFILLER_28_298 VPWR VGND sg13g2_decap_8
XFILLER_31_408 VPWR VGND sg13g2_decap_8
XFILLER_43_257 VPWR VGND sg13g2_decap_8
XFILLER_11_165 VPWR VGND sg13g2_decap_8
XFILLER_7_147 VPWR VGND sg13g2_decap_8
XFILLER_3_375 VPWR VGND sg13g2_decap_8
XFILLER_19_221 VPWR VGND sg13g2_decap_8
XFILLER_19_298 VPWR VGND sg13g2_decap_8
XFILLER_34_224 VPWR VGND sg13g2_decap_8
XFILLER_35_769 VPWR VGND sg13g2_decap_8
XFILLER_47_574 VPWR VGND sg13g2_decap_8
X_1010_ net112 VGND VPWR _0170_ state\[42\] clknet_5_18__leaf_clk sg13g2_dfrbpq_1
XFILLER_47_91 VPWR VGND sg13g2_decap_8
XFILLER_15_471 VPWR VGND sg13g2_decap_8
XFILLER_30_452 VPWR VGND sg13g2_decap_8
XFILLER_8_41 VPWR VGND sg13g2_decap_8
XFILLER_40_0 VPWR VGND sg13g2_decap_4
X_0725_ _0274_ VPWR _0133_ VGND net79 _0059_ sg13g2_o21ai_1
X_0656_ _0241_ net73 _0402_ _0403_ VPWR VGND sg13g2_a21o_1
XFILLER_26_714 VPWR VGND sg13g2_decap_8
XFILLER_38_574 VPWR VGND sg13g2_decap_8
X_0587_ net86 VPWR _0351_ VGND net65 state\[31\] sg13g2_o21ai_1
XFILLER_13_408 VPWR VGND sg13g2_decap_8
XFILLER_25_268 VPWR VGND sg13g2_decap_8
XFILLER_21_463 VPWR VGND sg13g2_decap_8
XFILLER_0_301 VPWR VGND sg13g2_decap_8
XFILLER_0_378 VPWR VGND sg13g2_decap_8
XFILLER_16_235 VPWR VGND sg13g2_decap_8
XFILLER_17_50 VPWR VGND sg13g2_decap_8
XFILLER_29_552 VPWR VGND sg13g2_decap_8
XFILLER_44_500 VPWR VGND sg13g2_decap_8
Xclkbuf_5_26__f_clk clknet_5_26__leaf_clk clknet_4_13_0_clk VPWR VGND sg13g2_buf_16
XFILLER_12_496 VPWR VGND sg13g2_decap_8
XFILLER_31_205 VPWR VGND sg13g2_decap_8
XFILLER_33_60 VPWR VGND sg13g2_decap_8
XFILLER_44_577 VPWR VGND sg13g2_decap_8
XFILLER_8_412 VPWR VGND sg13g2_decap_8
XFILLER_3_172 VPWR VGND sg13g2_decap_8
X_0510_ _0075_ _0292_ _0293_ net37 _0204_ VPWR VGND sg13g2_a22oi_1
XFILLER_8_489 VPWR VGND sg13g2_decap_8
XFILLER_12_4 VPWR VGND sg13g2_decap_4
XFILLER_39_327 VPWR VGND sg13g2_decap_8
XFILLER_22_238 VPWR VGND sg13g2_decap_8
XFILLER_35_511 VPWR VGND sg13g2_decap_8
XFILLER_35_588 VPWR VGND sg13g2_decap_8
XFILLER_47_371 VPWR VGND sg13g2_decap_8
X_0708_ _0254_ net55 _0441_ _0442_ VPWR VGND sg13g2_a21o_1
X_0639_ net91 VPWR _0390_ VGND net70 state\[44\] sg13g2_o21ai_1
XFILLER_26_511 VPWR VGND sg13g2_decap_8
XFILLER_38_371 VPWR VGND sg13g2_decap_8
XFILLER_38_49 VPWR VGND sg13g2_decap_8
XFILLER_45_308 VPWR VGND sg13g2_decap_8
XFILLER_13_205 VPWR VGND sg13g2_decap_8
XFILLER_21_260 VPWR VGND sg13g2_decap_8
XFILLER_26_588 VPWR VGND sg13g2_decap_8
XFILLER_41_503 VPWR VGND sg13g2_decap_8
XFILLER_5_459 VPWR VGND sg13g2_decap_8
XFILLER_0_175 VPWR VGND sg13g2_decap_8
XFILLER_36_308 VPWR VGND sg13g2_decap_8
XFILLER_48_168 VPWR VGND sg13g2_decap_8
XFILLER_17_533 VPWR VGND sg13g2_decap_8
XFILLER_28_60 VPWR VGND sg13g2_decap_8
XFILLER_32_536 VPWR VGND sg13g2_decap_8
XFILLER_44_352 VPWR VGND sg13g2_decap_8
XFILLER_12_293 VPWR VGND sg13g2_decap_8
X_0990_ net106 VGND VPWR _0150_ state\[22\] clknet_5_13__leaf_clk sg13g2_dfrbpq_1
XFILLER_9_743 VPWR VGND sg13g2_fill_1
XFILLER_8_286 VPWR VGND sg13g2_decap_8
XFILLER_5_53 VPWR VGND sg13g2_decap_8
XFILLER_39_124 VPWR VGND sg13g2_decap_8
XFILLER_23_547 VPWR VGND sg13g2_decap_8
XFILLER_35_385 VPWR VGND sg13g2_decap_8
XFILLER_18_308 VPWR VGND sg13g2_decap_8
XFILLER_26_385 VPWR VGND sg13g2_decap_8
XFILLER_41_300 VPWR VGND sg13g2_decap_8
XFILLER_45_105 VPWR VGND sg13g2_decap_8
XFILLER_10_742 VPWR VGND sg13g2_fill_2
XFILLER_14_51 VPWR VGND sg13g2_decap_8
XFILLER_14_569 VPWR VGND sg13g2_decap_8
XFILLER_41_377 VPWR VGND sg13g2_decap_8
XFILLER_1_462 VPWR VGND sg13g2_decap_8
XFILLER_5_256 VPWR VGND sg13g2_decap_8
XFILLER_17_330 VPWR VGND sg13g2_decap_8
XFILLER_36_105 VPWR VGND sg13g2_decap_8
XFILLER_49_466 VPWR VGND sg13g2_decap_8
XFILLER_20_528 VPWR VGND sg13g2_decap_8
XFILLER_32_333 VPWR VGND sg13g2_decap_8
XFILLER_45_650 VPWR VGND sg13g2_decap_4
X_0973_ net100 VGND VPWR _0133_ state\[5\] clknet_5_1__leaf_clk sg13g2_dfrbpq_1
XFILLER_28_606 VPWR VGND sg13g2_decap_8
XFILLER_35_182 VPWR VGND sg13g2_decap_8
XFILLER_35_28 VPWR VGND sg13g2_decap_8
XFILLER_23_344 VPWR VGND sg13g2_decap_8
XFILLER_18_105 VPWR VGND sg13g2_decap_8
XFILLER_19_606 VPWR VGND sg13g2_decap_8
XFILLER_14_366 VPWR VGND sg13g2_decap_8
XFILLER_25_72 VPWR VGND sg13g2_decap_8
XFILLER_26_182 VPWR VGND sg13g2_decap_8
XFILLER_27_650 VPWR VGND sg13g2_decap_8
XFILLER_34_609 VPWR VGND sg13g2_decap_8
XFILLER_42_642 VPWR VGND sg13g2_decap_8
XFILLER_46_469 VPWR VGND sg13g2_decap_8
XFILLER_2_32 VPWR VGND sg13g2_decap_8
XFILLER_44_7 VPWR VGND sg13g2_decap_8
Xheichips25_pudding VPWR VGND uio_oe[0] sg13g2_tiehi
XFILLER_18_672 VPWR VGND sg13g2_decap_8
XFILLER_24_119 VPWR VGND sg13g2_decap_8
XFILLER_33_620 VPWR VGND sg13g2_decap_8
XFILLER_37_469 VPWR VGND sg13g2_decap_8
XFILLER_49_263 VPWR VGND sg13g2_decap_8
XFILLER_20_325 VPWR VGND sg13g2_decap_8
XFILLER_32_130 VPWR VGND sg13g2_decap_8
X_0956_ net110 VGND VPWR _0116_ daisychain\[52\] clknet_5_30__leaf_clk sg13g2_dfrbpq_1
XFILLER_0_719 VPWR VGND sg13g2_decap_4
X_0887_ VPWR _0243_ daisychain\[50\] VGND sg13g2_inv_1
XFILLER_28_403 VPWR VGND sg13g2_decap_8
XFILLER_46_49 VPWR VGND sg13g2_decap_8
Xclkbuf_5_7__f_clk clknet_5_7__leaf_clk clknet_4_3_0_clk VPWR VGND sg13g2_buf_16
XFILLER_23_141 VPWR VGND sg13g2_decap_8
XFILLER_24_686 VPWR VGND sg13g2_decap_8
XFILLER_43_439 VPWR VGND sg13g2_decap_8
XFILLER_11_347 VPWR VGND sg13g2_decap_8
XFILLER_7_329 VPWR VGND sg13g2_decap_8
XFILLER_11_74 VPWR VGND sg13g2_decap_8
XFILLER_3_557 VPWR VGND sg13g2_decap_8
XFILLER_19_403 VPWR VGND sg13g2_decap_8
XFILLER_34_406 VPWR VGND sg13g2_decap_8
XFILLER_46_266 VPWR VGND sg13g2_decap_8
XFILLER_14_163 VPWR VGND sg13g2_decap_8
XFILLER_15_675 VPWR VGND sg13g2_fill_2
XFILLER_30_634 VPWR VGND sg13g2_decap_8
XFILLER_42_483 VPWR VGND sg13g2_decap_8
X_0810_ VPWR _0035_ state\[12\] VGND sg13g2_inv_1
XFILLER_10_391 VPWR VGND sg13g2_decap_8
X_0741_ _0322_ VPWR _0149_ VGND net85 _0045_ sg13g2_o21ai_1
X_0672_ _0245_ net69 _0414_ _0415_ VPWR VGND sg13g2_a21o_1
XFILLER_6_351 VPWR VGND sg13g2_decap_8
XFILLER_38_701 VPWR VGND sg13g2_decap_4
XFILLER_16_19 VPWR VGND sg13g2_fill_2
XFILLER_25_439 VPWR VGND sg13g2_decap_8
XFILLER_37_266 VPWR VGND sg13g2_decap_8
XFILLER_20_122 VPWR VGND sg13g2_decap_8
XFILLER_20_199 VPWR VGND sg13g2_decap_8
XFILLER_21_645 VPWR VGND sg13g2_decap_8
XFILLER_32_18 VPWR VGND sg13g2_decap_8
XFILLER_33_494 VPWR VGND sg13g2_decap_8
X_0939_ net110 VGND VPWR _0099_ daisychain\[35\] clknet_5_25__leaf_clk sg13g2_dfrbpq_1
XFILLER_16_417 VPWR VGND sg13g2_decap_8
XFILLER_28_200 VPWR VGND sg13g2_decap_8
XFILLER_28_277 VPWR VGND sg13g2_decap_8
Xclkbuf_4_5_0_clk clknet_0_clk clknet_4_5_0_clk VPWR VGND sg13g2_buf_8
XFILLER_11_144 VPWR VGND sg13g2_decap_8
XFILLER_12_601 VPWR VGND sg13g2_decap_8
XFILLER_24_483 VPWR VGND sg13g2_decap_8
XFILLER_43_236 VPWR VGND sg13g2_decap_8
XFILLER_22_84 VPWR VGND sg13g2_decap_8
XFILLER_3_354 VPWR VGND sg13g2_decap_8
XFILLER_7_126 VPWR VGND sg13g2_decap_8
XFILLER_0_0 VPWR VGND sg13g2_decap_8
XFILLER_14_8 VPWR VGND sg13g2_fill_2
XFILLER_19_200 VPWR VGND sg13g2_decap_8
XFILLER_15_450 VPWR VGND sg13g2_decap_8
XFILLER_19_277 VPWR VGND sg13g2_decap_8
XFILLER_34_203 VPWR VGND sg13g2_decap_8
XFILLER_47_553 VPWR VGND sg13g2_decap_8
XFILLER_47_70 VPWR VGND sg13g2_decap_8
XFILLER_30_431 VPWR VGND sg13g2_decap_8
XFILLER_42_280 VPWR VGND sg13g2_decap_8
XFILLER_8_97 VPWR VGND sg13g2_decap_8
XFILLER_8_20 VPWR VGND sg13g2_decap_8
X_0724_ _0271_ VPWR _0132_ VGND net78 _0058_ sg13g2_o21ai_1
X_0655_ net94 VPWR _0402_ VGND net73 state\[48\] sg13g2_o21ai_1
X_0586_ _0094_ _0349_ _0350_ net46 _0223_ VPWR VGND sg13g2_a22oi_1
XFILLER_38_553 VPWR VGND sg13g2_decap_8
XFILLER_21_442 VPWR VGND sg13g2_decap_8
XFILLER_25_247 VPWR VGND sg13g2_decap_8
XFILLER_33_291 VPWR VGND sg13g2_decap_8
XFILLER_40_239 VPWR VGND sg13g2_decap_8
XFILLER_0_357 VPWR VGND sg13g2_decap_8
XFILLER_29_531 VPWR VGND sg13g2_decap_8
XFILLER_16_214 VPWR VGND sg13g2_decap_8
XFILLER_44_556 VPWR VGND sg13g2_decap_8
XFILLER_12_475 VPWR VGND sg13g2_decap_8
XFILLER_24_280 VPWR VGND sg13g2_decap_8
XFILLER_8_468 VPWR VGND sg13g2_decap_8
XFILLER_3_151 VPWR VGND sg13g2_decap_8
XFILLER_39_306 VPWR VGND sg13g2_decap_8
XFILLER_47_350 VPWR VGND sg13g2_decap_8
XFILLER_22_217 VPWR VGND sg13g2_decap_8
XFILLER_23_718 VPWR VGND sg13g2_decap_8
XFILLER_31_751 VPWR VGND sg13g2_fill_2
XFILLER_31_762 VPWR VGND sg13g2_fill_1
XFILLER_35_567 VPWR VGND sg13g2_decap_8
X_0707_ net77 VPWR _0441_ VGND net55 state\[61\] sg13g2_o21ai_1
XFILLER_7_490 VPWR VGND sg13g2_decap_8
XFILLER_38_28 VPWR VGND sg13g2_decap_8
X_0638_ _0107_ _0388_ _0389_ net50 _0236_ VPWR VGND sg13g2_a22oi_1
X_0569_ VGND VPWR net24 daisychain\[25\] _0338_ net39 sg13g2_a21oi_1
XFILLER_26_567 VPWR VGND sg13g2_decap_8
XFILLER_38_350 VPWR VGND sg13g2_decap_8
XFILLER_5_438 VPWR VGND sg13g2_decap_8
XFILLER_0_154 VPWR VGND sg13g2_decap_8
XFILLER_17_512 VPWR VGND sg13g2_decap_8
XFILLER_49_648 VPWR VGND sg13g2_decap_8
XFILLER_48_147 VPWR VGND sg13g2_decap_8
XFILLER_17_589 VPWR VGND sg13g2_decap_8
XFILLER_32_515 VPWR VGND sg13g2_decap_8
XFILLER_44_331 VPWR VGND sg13g2_decap_8
XFILLER_44_93 VPWR VGND sg13g2_decap_8
XFILLER_9_700 VPWR VGND sg13g2_fill_1
XFILLER_12_272 VPWR VGND sg13g2_decap_8
XFILLER_9_722 VPWR VGND sg13g2_decap_8
XFILLER_8_265 VPWR VGND sg13g2_decap_8
XFILLER_39_103 VPWR VGND sg13g2_decap_8
XFILLER_5_32 VPWR VGND sg13g2_decap_8
XFILLER_35_364 VPWR VGND sg13g2_decap_8
XFILLER_10_209 VPWR VGND sg13g2_decap_8
XFILLER_23_526 VPWR VGND sg13g2_decap_8
XFILLER_40_29 VPWR VGND sg13g2_decap_8
XFILLER_27_810 VPWR VGND sg13g2_decap_8
XFILLER_27_821 VPWR VGND sg13g2_fill_2
XFILLER_14_548 VPWR VGND sg13g2_decap_8
XFILLER_26_364 VPWR VGND sg13g2_decap_8
XFILLER_41_356 VPWR VGND sg13g2_decap_8
XFILLER_10_721 VPWR VGND sg13g2_decap_8
XFILLER_22_581 VPWR VGND sg13g2_decap_8
XFILLER_5_235 VPWR VGND sg13g2_decap_8
XFILLER_1_441 VPWR VGND sg13g2_decap_8
XFILLER_30_95 VPWR VGND sg13g2_decap_8
XFILLER_37_618 VPWR VGND sg13g2_fill_1
XFILLER_39_82 VPWR VGND sg13g2_decap_8
XFILLER_49_445 VPWR VGND sg13g2_decap_8
XFILLER_17_386 VPWR VGND sg13g2_decap_8
XFILLER_20_507 VPWR VGND sg13g2_decap_8
XFILLER_32_312 VPWR VGND sg13g2_decap_8
XFILLER_32_389 VPWR VGND sg13g2_decap_8
X_0972_ net100 VGND VPWR _0132_ state\[4\] clknet_5_3__leaf_clk sg13g2_dfrbpq_1
XFILLER_23_323 VPWR VGND sg13g2_decap_8
XFILLER_27_139 VPWR VGND sg13g2_decap_8
XFILLER_35_161 VPWR VGND sg13g2_decap_8
XFILLER_36_695 VPWR VGND sg13g2_decap_4
XFILLER_11_529 VPWR VGND sg13g2_decap_8
XFILLER_2_249 VPWR VGND sg13g2_decap_8
XFILLER_33_109 VPWR VGND sg13g2_decap_8
XFILLER_46_448 VPWR VGND sg13g2_decap_8
XFILLER_14_345 VPWR VGND sg13g2_decap_8
XFILLER_25_51 VPWR VGND sg13g2_decap_8
XFILLER_26_161 VPWR VGND sg13g2_decap_8
XFILLER_41_175 VPWR VGND sg13g2_decap_4
XFILLER_10_573 VPWR VGND sg13g2_decap_8
XFILLER_6_544 VPWR VGND sg13g2_fill_2
XFILLER_2_11 VPWR VGND sg13g2_decap_8
XFILLER_37_7 VPWR VGND sg13g2_decap_8
XFILLER_49_242 VPWR VGND sg13g2_decap_8
XFILLER_17_183 VPWR VGND sg13g2_decap_8
XFILLER_18_651 VPWR VGND sg13g2_decap_8
XFILLER_2_88 VPWR VGND sg13g2_decap_8
XFILLER_37_448 VPWR VGND sg13g2_decap_8
XFILLER_20_304 VPWR VGND sg13g2_decap_8
XFILLER_32_186 VPWR VGND sg13g2_decap_8
X_0886_ VPWR _0009_ state\[50\] VGND sg13g2_inv_1
X_0955_ net109 VGND VPWR _0115_ daisychain\[51\] clknet_5_22__leaf_clk sg13g2_dfrbpq_1
XFILLER_9_382 VPWR VGND sg13g2_decap_8
XFILLER_28_459 VPWR VGND sg13g2_decap_8
XFILLER_46_28 VPWR VGND sg13g2_decap_8
XFILLER_11_326 VPWR VGND sg13g2_decap_8
XFILLER_23_120 VPWR VGND sg13g2_decap_8
XFILLER_23_197 VPWR VGND sg13g2_decap_8
XFILLER_24_665 VPWR VGND sg13g2_decap_8
XFILLER_43_418 VPWR VGND sg13g2_decap_8
XFILLER_11_53 VPWR VGND sg13g2_decap_8
XFILLER_3_536 VPWR VGND sg13g2_decap_8
XFILLER_7_308 VPWR VGND sg13g2_decap_8
XFILLER_2_4 VPWR VGND sg13g2_decap_8
XFILLER_15_621 VPWR VGND sg13g2_fill_2
XFILLER_19_459 VPWR VGND sg13g2_decap_8
XFILLER_46_245 VPWR VGND sg13g2_decap_8
XFILLER_10_370 VPWR VGND sg13g2_decap_8
XFILLER_14_142 VPWR VGND sg13g2_decap_8
XFILLER_30_613 VPWR VGND sg13g2_decap_8
XFILLER_42_462 VPWR VGND sg13g2_decap_8
X_0740_ _0319_ VPWR _0148_ VGND net85 _0044_ sg13g2_o21ai_1
X_0671_ net88 VPWR _0414_ VGND net67 state\[52\] sg13g2_o21ai_1
XFILLER_6_330 VPWR VGND sg13g2_decap_8
XFILLER_37_245 VPWR VGND sg13g2_decap_8
XFILLER_20_101 VPWR VGND sg13g2_decap_8
XFILLER_21_624 VPWR VGND sg13g2_decap_8
XFILLER_33_473 VPWR VGND sg13g2_decap_8
XFILLER_20_178 VPWR VGND sg13g2_decap_8
X_0869_ VPWR _0234_ daisychain\[41\] VGND sg13g2_inv_1
X_0938_ net111 VGND VPWR _0098_ daisychain\[34\] clknet_5_29__leaf_clk sg13g2_dfrbpq_1
XFILLER_0_539 VPWR VGND sg13g2_decap_8
XFILLER_29_713 VPWR VGND sg13g2_decap_8
XFILLER_28_256 VPWR VGND sg13g2_decap_8
XFILLER_29_735 VPWR VGND sg13g2_decap_8
XFILLER_43_215 VPWR VGND sg13g2_decap_8
XFILLER_44_705 VPWR VGND sg13g2_fill_1
XFILLER_11_123 VPWR VGND sg13g2_decap_8
XFILLER_24_462 VPWR VGND sg13g2_decap_8
XFILLER_7_105 VPWR VGND sg13g2_decap_8
XFILLER_22_63 VPWR VGND sg13g2_decap_8
XFILLER_3_333 VPWR VGND sg13g2_decap_8
XFILLER_19_256 VPWR VGND sg13g2_decap_8
XFILLER_35_705 VPWR VGND sg13g2_fill_2
XFILLER_47_532 VPWR VGND sg13g2_decap_8
XFILLER_30_410 VPWR VGND sg13g2_decap_8
XFILLER_34_259 VPWR VGND sg13g2_decap_8
XFILLER_30_487 VPWR VGND sg13g2_decap_8
X_0723_ _0268_ VPWR _0131_ VGND net78 _0057_ sg13g2_o21ai_1
XFILLER_8_76 VPWR VGND sg13g2_decap_8
X_0654_ _0111_ _0400_ _0401_ net51 _0240_ VPWR VGND sg13g2_a22oi_1
X_0585_ VGND VPWR net24 daisychain\[29\] _0350_ net46 sg13g2_a21oi_1
XFILLER_25_226 VPWR VGND sg13g2_decap_8
XFILLER_38_532 VPWR VGND sg13g2_decap_8
XFILLER_21_421 VPWR VGND sg13g2_decap_8
XFILLER_21_498 VPWR VGND sg13g2_decap_8
XFILLER_33_270 VPWR VGND sg13g2_decap_8
XFILLER_40_218 VPWR VGND sg13g2_decap_8
XFILLER_41_719 VPWR VGND sg13g2_fill_1
XFILLER_0_336 VPWR VGND sg13g2_decap_8
XFILLER_29_510 VPWR VGND sg13g2_decap_8
XFILLER_49_819 VPWR VGND sg13g2_decap_4
XFILLER_48_329 VPWR VGND sg13g2_decap_8
XFILLER_17_727 VPWR VGND sg13g2_fill_2
XFILLER_17_85 VPWR VGND sg13g2_decap_8
XFILLER_25_771 VPWR VGND sg13g2_fill_1
XFILLER_25_782 VPWR VGND sg13g2_decap_4
XFILLER_25_793 VPWR VGND sg13g2_fill_2
XFILLER_29_587 VPWR VGND sg13g2_decap_8
XFILLER_44_535 VPWR VGND sg13g2_decap_8
XFILLER_12_454 VPWR VGND sg13g2_decap_8
XFILLER_33_95 VPWR VGND sg13g2_decap_8
XFILLER_8_447 VPWR VGND sg13g2_decap_8
XFILLER_3_130 VPWR VGND sg13g2_decap_8
XFILLER_4_686 VPWR VGND sg13g2_fill_1
XFILLER_4_642 VPWR VGND sg13g2_fill_1
XFILLER_35_546 VPWR VGND sg13g2_decap_8
XFILLER_23_708 VPWR VGND sg13g2_fill_1
XFILLER_31_796 VPWR VGND sg13g2_fill_2
XFILLER_30_284 VPWR VGND sg13g2_decap_8
Xclkbuf_4_4_0_clk clknet_0_clk clknet_4_4_0_clk VPWR VGND sg13g2_buf_8
X_0706_ _0124_ _0439_ _0440_ net35 _0253_ VPWR VGND sg13g2_a22oi_1
XFILLER_38_18 VPWR VGND sg13g2_fill_1
X_0637_ VGND VPWR net28 daisychain\[42\] _0389_ net50 sg13g2_a21oi_1
X_0568_ _0219_ net58 _0336_ _0337_ VPWR VGND sg13g2_a21o_1
X_0499_ net82 VPWR _0285_ VGND net61 state\[9\] sg13g2_o21ai_1
XFILLER_26_546 VPWR VGND sg13g2_decap_8
XFILLER_21_295 VPWR VGND sg13g2_decap_8
XFILLER_5_417 VPWR VGND sg13g2_decap_8
XFILLER_0_133 VPWR VGND sg13g2_decap_8
XFILLER_28_95 VPWR VGND sg13g2_decap_8
XFILLER_29_384 VPWR VGND sg13g2_decap_8
XFILLER_44_310 VPWR VGND sg13g2_decap_8
XFILLER_49_627 VPWR VGND sg13g2_decap_8
XFILLER_48_126 VPWR VGND sg13g2_decap_8
XFILLER_12_251 VPWR VGND sg13g2_decap_8
XFILLER_13_774 VPWR VGND sg13g2_fill_2
XFILLER_17_568 VPWR VGND sg13g2_decap_8
XFILLER_44_387 VPWR VGND sg13g2_decap_8
XFILLER_44_72 VPWR VGND sg13g2_decap_8
XFILLER_40_582 VPWR VGND sg13g2_decap_8
XFILLER_8_244 VPWR VGND sg13g2_decap_8
XFILLER_5_11 VPWR VGND sg13g2_decap_8
XFILLER_39_159 VPWR VGND sg13g2_decap_8
XFILLER_5_88 VPWR VGND sg13g2_decap_8
XFILLER_4_494 VPWR VGND sg13g2_decap_8
XFILLER_23_505 VPWR VGND sg13g2_decap_8
XFILLER_35_343 VPWR VGND sg13g2_decap_8
XFILLER_36_811 VPWR VGND sg13g2_decap_8
XFILLER_36_822 VPWR VGND sg13g2_fill_1
XFILLER_49_39 VPWR VGND sg13g2_decap_8
XFILLER_10_700 VPWR VGND sg13g2_fill_1
XFILLER_14_527 VPWR VGND sg13g2_decap_8
XFILLER_22_560 VPWR VGND sg13g2_decap_8
XFILLER_26_343 VPWR VGND sg13g2_decap_8
XFILLER_41_335 VPWR VGND sg13g2_decap_8
XFILLER_14_86 VPWR VGND sg13g2_decap_8
XFILLER_30_74 VPWR VGND sg13g2_decap_8
XFILLER_5_214 VPWR VGND sg13g2_decap_8
XFILLER_1_420 VPWR VGND sg13g2_decap_8
XFILLER_1_497 VPWR VGND sg13g2_decap_8
XFILLER_39_61 VPWR VGND sg13g2_decap_8
XFILLER_49_424 VPWR VGND sg13g2_decap_8
XFILLER_17_365 VPWR VGND sg13g2_decap_8
XFILLER_18_822 VPWR VGND sg13g2_fill_1
XFILLER_29_181 VPWR VGND sg13g2_decap_8
XFILLER_32_368 VPWR VGND sg13g2_decap_8
XFILLER_44_184 VPWR VGND sg13g2_decap_8
X_0971_ net99 VGND VPWR _0131_ state\[3\] clknet_5_3__leaf_clk sg13g2_dfrbpq_1
XFILLER_9_564 VPWR VGND sg13g2_decap_8
XFILLER_4_291 VPWR VGND sg13g2_decap_8
XFILLER_27_118 VPWR VGND sg13g2_decap_8
XFILLER_36_630 VPWR VGND sg13g2_decap_4
XFILLER_48_490 VPWR VGND sg13g2_decap_8
XFILLER_11_508 VPWR VGND sg13g2_decap_8
XFILLER_23_302 VPWR VGND sg13g2_decap_8
XFILLER_23_379 VPWR VGND sg13g2_decap_8
XFILLER_35_140 VPWR VGND sg13g2_decap_8
XFILLER_2_228 VPWR VGND sg13g2_decap_8
XFILLER_26_140 VPWR VGND sg13g2_decap_8
XFILLER_27_685 VPWR VGND sg13g2_decap_8
XFILLER_46_427 VPWR VGND sg13g2_decap_8
XFILLER_10_552 VPWR VGND sg13g2_decap_8
XFILLER_14_324 VPWR VGND sg13g2_decap_8
XFILLER_41_154 VPWR VGND sg13g2_decap_8
XFILLER_42_699 VPWR VGND sg13g2_fill_1
XFILLER_10_585 VPWR VGND sg13g2_decap_8
XFILLER_41_84 VPWR VGND sg13g2_decap_8
XFILLER_1_294 VPWR VGND sg13g2_decap_8
XFILLER_2_67 VPWR VGND sg13g2_decap_8
XFILLER_2_795 VPWR VGND sg13g2_fill_2
XFILLER_37_427 VPWR VGND sg13g2_decap_8
XFILLER_49_298 VPWR VGND sg13g2_decap_8
XFILLER_49_221 VPWR VGND sg13g2_decap_8
XFILLER_17_162 VPWR VGND sg13g2_decap_8
XFILLER_18_630 VPWR VGND sg13g2_decap_8
XFILLER_21_806 VPWR VGND sg13g2_decap_8
XFILLER_32_165 VPWR VGND sg13g2_decap_8
XFILLER_33_655 VPWR VGND sg13g2_decap_8
X_0885_ VPWR _0242_ daisychain\[49\] VGND sg13g2_inv_1
X_0954_ net109 VGND VPWR _0114_ daisychain\[50\] clknet_5_22__leaf_clk sg13g2_dfrbpq_1
XFILLER_9_361 VPWR VGND sg13g2_decap_8
XFILLER_28_438 VPWR VGND sg13g2_decap_8
XFILLER_11_305 VPWR VGND sg13g2_decap_8
XFILLER_23_176 VPWR VGND sg13g2_decap_8
XFILLER_24_644 VPWR VGND sg13g2_decap_8
XFILLER_11_32 VPWR VGND sg13g2_decap_8
XFILLER_3_515 VPWR VGND sg13g2_decap_8
XFILLER_19_438 VPWR VGND sg13g2_decap_8
XFILLER_46_224 VPWR VGND sg13g2_decap_8
XFILLER_47_703 VPWR VGND sg13g2_fill_2
XFILLER_14_121 VPWR VGND sg13g2_decap_8
XFILLER_15_600 VPWR VGND sg13g2_decap_8
XFILLER_27_482 VPWR VGND sg13g2_decap_8
XFILLER_36_84 VPWR VGND sg13g2_decap_8
XFILLER_42_441 VPWR VGND sg13g2_decap_8
XFILLER_14_198 VPWR VGND sg13g2_decap_8
XFILLER_30_669 VPWR VGND sg13g2_decap_8
X_0670_ _0115_ _0412_ _0413_ net47 _0244_ VPWR VGND sg13g2_a22oi_1
XFILLER_6_386 VPWR VGND sg13g2_decap_8
XFILLER_25_408 VPWR VGND sg13g2_decap_4
XFILLER_28_4 VPWR VGND sg13g2_decap_8
XFILLER_37_224 VPWR VGND sg13g2_decap_8
XFILLER_20_157 VPWR VGND sg13g2_decap_8
XFILLER_21_603 VPWR VGND sg13g2_decap_8
XFILLER_33_452 VPWR VGND sg13g2_decap_8
X_0868_ VPWR _0031_ state\[41\] VGND sg13g2_inv_1
X_0937_ net111 VGND VPWR _0097_ daisychain\[33\] clknet_5_29__leaf_clk sg13g2_dfrbpq_1
Xclkbuf_5_15__f_clk clknet_5_15__leaf_clk clknet_4_7_0_clk VPWR VGND sg13g2_buf_16
X_0799_ VPWR _0199_ daisychain\[6\] VGND sg13g2_inv_1
XFILLER_0_518 VPWR VGND sg13g2_decap_8
XFILLER_24_441 VPWR VGND sg13g2_decap_8
XFILLER_28_235 VPWR VGND sg13g2_decap_8
XFILLER_11_102 VPWR VGND sg13g2_decap_8
XFILLER_11_179 VPWR VGND sg13g2_decap_8
XFILLER_22_42 VPWR VGND sg13g2_decap_8
XFILLER_3_312 VPWR VGND sg13g2_decap_8
XFILLER_3_389 VPWR VGND sg13g2_decap_8
XFILLER_19_235 VPWR VGND sg13g2_decap_8
XFILLER_47_511 VPWR VGND sg13g2_decap_8
XFILLER_47_588 VPWR VGND sg13g2_decap_8
XFILLER_15_485 VPWR VGND sg13g2_decap_8
XFILLER_34_238 VPWR VGND sg13g2_decap_8
Xheichips25_pudding_118 VPWR VGND uio_oe[1] sg13g2_tiehi
XFILLER_30_466 VPWR VGND sg13g2_decap_8
X_0722_ _0265_ VPWR _0130_ VGND net78 _0054_ sg13g2_o21ai_1
X_0653_ VGND VPWR net28 daisychain\[46\] _0401_ net53 sg13g2_a21oi_1
XFILLER_8_55 VPWR VGND sg13g2_decap_8
XFILLER_7_651 VPWR VGND sg13g2_fill_2
XFILLER_6_183 VPWR VGND sg13g2_decap_8
XFILLER_38_511 VPWR VGND sg13g2_decap_8
X_0584_ _0223_ net66 _0348_ _0349_ VPWR VGND sg13g2_a21o_1
XFILLER_25_205 VPWR VGND sg13g2_decap_8
XFILLER_26_728 VPWR VGND sg13g2_decap_8
XFILLER_38_588 VPWR VGND sg13g2_decap_8
XFILLER_21_400 VPWR VGND sg13g2_decap_8
XFILLER_21_477 VPWR VGND sg13g2_decap_8
XFILLER_0_315 VPWR VGND sg13g2_decap_8
XFILLER_4_109 VPWR VGND sg13g2_decap_8
XFILLER_29_566 VPWR VGND sg13g2_decap_8
XFILLER_44_514 VPWR VGND sg13g2_decap_8
XFILLER_48_308 VPWR VGND sg13g2_decap_8
XFILLER_12_433 VPWR VGND sg13g2_decap_8
XFILLER_16_249 VPWR VGND sg13g2_decap_8
XFILLER_17_64 VPWR VGND sg13g2_decap_8
XFILLER_31_219 VPWR VGND sg13g2_decap_8
XFILLER_33_74 VPWR VGND sg13g2_decap_8
XFILLER_8_426 VPWR VGND sg13g2_decap_8
XFILLER_3_186 VPWR VGND sg13g2_decap_8
XFILLER_35_525 VPWR VGND sg13g2_decap_8
XFILLER_47_385 VPWR VGND sg13g2_decap_8
XFILLER_15_282 VPWR VGND sg13g2_decap_8
XFILLER_16_772 VPWR VGND sg13g2_decap_4
XFILLER_30_263 VPWR VGND sg13g2_decap_8
XFILLER_31_753 VPWR VGND sg13g2_fill_1
X_0705_ VGND VPWR net33 daisychain\[59\] _0440_ net35 sg13g2_a21oi_1
X_0636_ _0236_ net70 _0387_ _0388_ VPWR VGND sg13g2_a21o_1
X_0567_ net80 VPWR _0336_ VGND net58 state\[26\] sg13g2_o21ai_1
X_0498_ _0072_ _0283_ _0284_ net37 _0201_ VPWR VGND sg13g2_a22oi_1
XFILLER_13_219 VPWR VGND sg13g2_decap_8
XFILLER_26_525 VPWR VGND sg13g2_decap_8
XFILLER_41_517 VPWR VGND sg13g2_decap_4
XFILLER_21_274 VPWR VGND sg13g2_decap_8
XFILLER_0_112 VPWR VGND sg13g2_decap_8
XFILLER_49_606 VPWR VGND sg13g2_decap_8
XFILLER_48_105 VPWR VGND sg13g2_decap_8
XFILLER_0_189 VPWR VGND sg13g2_decap_8
XFILLER_17_547 VPWR VGND sg13g2_decap_8
XFILLER_28_74 VPWR VGND sg13g2_decap_8
XFILLER_29_363 VPWR VGND sg13g2_decap_8
XFILLER_44_366 VPWR VGND sg13g2_decap_8
XFILLER_12_230 VPWR VGND sg13g2_decap_8
XFILLER_40_561 VPWR VGND sg13g2_decap_8
XFILLER_8_223 VPWR VGND sg13g2_decap_8
XFILLER_5_67 VPWR VGND sg13g2_decap_8
XFILLER_4_473 VPWR VGND sg13g2_decap_8
XFILLER_10_4 VPWR VGND sg13g2_decap_4
XFILLER_39_138 VPWR VGND sg13g2_decap_8
XFILLER_35_322 VPWR VGND sg13g2_decap_8
XFILLER_35_399 VPWR VGND sg13g2_decap_8
XFILLER_47_182 VPWR VGND sg13g2_decap_8
XFILLER_31_583 VPWR VGND sg13g2_decap_8
X_0619_ net93 VPWR _0375_ VGND net72 state\[39\] sg13g2_o21ai_1
XFILLER_49_18 VPWR VGND sg13g2_decap_8
XFILLER_26_322 VPWR VGND sg13g2_decap_8
XFILLER_38_182 VPWR VGND sg13g2_decap_8
XFILLER_45_119 VPWR VGND sg13g2_decap_8
XFILLER_46_609 VPWR VGND sg13g2_decap_8
XFILLER_14_506 VPWR VGND sg13g2_decap_8
XFILLER_14_65 VPWR VGND sg13g2_decap_8
XFILLER_26_399 VPWR VGND sg13g2_decap_8
XFILLER_41_314 VPWR VGND sg13g2_decap_8
XFILLER_30_53 VPWR VGND sg13g2_decap_8
XFILLER_1_476 VPWR VGND sg13g2_decap_8
XFILLER_37_609 VPWR VGND sg13g2_decap_8
XFILLER_39_40 VPWR VGND sg13g2_decap_8
Xclkbuf_4_3_0_clk clknet_0_clk clknet_4_3_0_clk VPWR VGND sg13g2_buf_8
XFILLER_49_403 VPWR VGND sg13g2_decap_8
XFILLER_17_344 VPWR VGND sg13g2_decap_8
XFILLER_29_160 VPWR VGND sg13g2_decap_8
XFILLER_32_347 VPWR VGND sg13g2_decap_8
XFILLER_33_815 VPWR VGND sg13g2_decap_8
XFILLER_36_119 VPWR VGND sg13g2_decap_8
XFILLER_44_163 VPWR VGND sg13g2_decap_8
XFILLER_45_686 VPWR VGND sg13g2_decap_8
XFILLER_13_583 VPWR VGND sg13g2_decap_8
X_0970_ net99 VGND VPWR _0130_ state\[2\] clknet_5_2__leaf_clk sg13g2_dfrbpq_1
XFILLER_9_543 VPWR VGND sg13g2_decap_8
XFILLER_4_270 VPWR VGND sg13g2_decap_8
XFILLER_23_358 VPWR VGND sg13g2_decap_8
XFILLER_31_380 VPWR VGND sg13g2_decap_8
XFILLER_35_196 VPWR VGND sg13g2_decap_8
XFILLER_2_207 VPWR VGND sg13g2_decap_8
XFILLER_46_406 VPWR VGND sg13g2_decap_8
XFILLER_14_303 VPWR VGND sg13g2_decap_8
XFILLER_15_804 VPWR VGND sg13g2_decap_8
XFILLER_18_119 VPWR VGND sg13g2_decap_8
XFILLER_26_196 VPWR VGND sg13g2_decap_8
XFILLER_27_664 VPWR VGND sg13g2_decap_8
XFILLER_10_531 VPWR VGND sg13g2_decap_8
XFILLER_25_86 VPWR VGND sg13g2_decap_8
XFILLER_30_807 VPWR VGND sg13g2_decap_8
XFILLER_41_133 VPWR VGND sg13g2_decap_8
XFILLER_41_63 VPWR VGND sg13g2_decap_8
XFILLER_1_273 VPWR VGND sg13g2_decap_8
XFILLER_2_46 VPWR VGND sg13g2_decap_8
XFILLER_37_406 VPWR VGND sg13g2_decap_8
XFILLER_49_277 VPWR VGND sg13g2_decap_8
XFILLER_49_200 VPWR VGND sg13g2_decap_8
XFILLER_17_141 VPWR VGND sg13g2_decap_8
XFILLER_18_686 VPWR VGND sg13g2_fill_1
XFILLER_20_339 VPWR VGND sg13g2_decap_8
XFILLER_32_144 VPWR VGND sg13g2_decap_8
XFILLER_33_634 VPWR VGND sg13g2_decap_8
XFILLER_45_483 VPWR VGND sg13g2_decap_8
XFILLER_13_380 VPWR VGND sg13g2_decap_8
X_0884_ VPWR _0008_ state\[49\] VGND sg13g2_inv_1
X_0953_ net114 VGND VPWR _0113_ daisychain\[49\] clknet_5_23__leaf_clk sg13g2_dfrbpq_1
XFILLER_9_340 VPWR VGND sg13g2_decap_8
XFILLER_24_623 VPWR VGND sg13g2_decap_8
XFILLER_28_417 VPWR VGND sg13g2_decap_8
XFILLER_36_483 VPWR VGND sg13g2_decap_8
XFILLER_23_155 VPWR VGND sg13g2_decap_8
XFILLER_11_11 VPWR VGND sg13g2_decap_8
XFILLER_11_88 VPWR VGND sg13g2_decap_8
XFILLER_19_417 VPWR VGND sg13g2_decap_8
XFILLER_46_203 VPWR VGND sg13g2_decap_8
XFILLER_14_100 VPWR VGND sg13g2_decap_8
XFILLER_14_177 VPWR VGND sg13g2_decap_8
XFILLER_15_623 VPWR VGND sg13g2_fill_1
XFILLER_27_461 VPWR VGND sg13g2_decap_8
XFILLER_36_63 VPWR VGND sg13g2_decap_8
XFILLER_42_420 VPWR VGND sg13g2_decap_8
XFILLER_42_497 VPWR VGND sg13g2_decap_8
XFILLER_30_648 VPWR VGND sg13g2_decap_8
XFILLER_6_365 VPWR VGND sg13g2_decap_8
XFILLER_18_483 VPWR VGND sg13g2_decap_8
XFILLER_37_203 VPWR VGND sg13g2_decap_8
XFILLER_45_280 VPWR VGND sg13g2_decap_8
XFILLER_20_136 VPWR VGND sg13g2_decap_8
XFILLER_21_659 VPWR VGND sg13g2_decap_8
XFILLER_33_431 VPWR VGND sg13g2_decap_8
X_0936_ net111 VGND VPWR _0096_ daisychain\[32\] clknet_5_20__leaf_clk sg13g2_dfrbpq_1
X_0867_ VPWR _0233_ daisychain\[40\] VGND sg13g2_inv_1
X_0798_ VPWR _0060_ state\[6\] VGND sg13g2_inv_1
XFILLER_28_214 VPWR VGND sg13g2_decap_8
XFILLER_24_420 VPWR VGND sg13g2_decap_8
XFILLER_24_497 VPWR VGND sg13g2_decap_8
XFILLER_36_280 VPWR VGND sg13g2_decap_8
XFILLER_11_158 VPWR VGND sg13g2_decap_8
XFILLER_22_98 VPWR VGND sg13g2_decap_8
XFILLER_3_368 VPWR VGND sg13g2_decap_8
XFILLER_19_214 VPWR VGND sg13g2_decap_8
XFILLER_34_217 VPWR VGND sg13g2_decap_8
XFILLER_47_567 VPWR VGND sg13g2_decap_8
XFILLER_47_84 VPWR VGND sg13g2_decap_8
XFILLER_15_464 VPWR VGND sg13g2_decap_8
XFILLER_30_445 VPWR VGND sg13g2_decap_8
XFILLER_42_294 VPWR VGND sg13g2_decap_8
Xclkbuf_5_21__f_clk clknet_5_21__leaf_clk clknet_4_10_0_clk VPWR VGND sg13g2_buf_16
Xheichips25_pudding_119 VPWR VGND uio_oe[2] sg13g2_tiehi
XFILLER_8_34 VPWR VGND sg13g2_decap_8
XFILLER_40_4 VPWR VGND sg13g2_fill_1
X_0721_ _0262_ VPWR _0129_ VGND net78 _0043_ sg13g2_o21ai_1
X_0652_ _0240_ net73 _0399_ _0400_ VPWR VGND sg13g2_a21o_1
X_0583_ net81 VPWR _0348_ VGND net60 state\[30\] sg13g2_o21ai_1
XFILLER_6_162 VPWR VGND sg13g2_decap_8
XFILLER_18_280 VPWR VGND sg13g2_decap_8
XFILLER_26_707 VPWR VGND sg13g2_decap_8
XFILLER_38_567 VPWR VGND sg13g2_decap_8
Xdigitalen.g\[0\].u.inv1 VPWR digitalen.g\[0\].u.OUTN net6 VGND sg13g2_inv_1
XFILLER_21_456 VPWR VGND sg13g2_decap_8
X_0919_ net105 VGND VPWR _0079_ daisychain\[15\] clknet_5_7__leaf_clk sg13g2_dfrbpq_1
XFILLER_16_228 VPWR VGND sg13g2_decap_8
XFILLER_17_43 VPWR VGND sg13g2_decap_8
XFILLER_29_545 VPWR VGND sg13g2_decap_8
XFILLER_12_412 VPWR VGND sg13g2_decap_8
XFILLER_24_294 VPWR VGND sg13g2_decap_8
XFILLER_33_53 VPWR VGND sg13g2_decap_8
XFILLER_8_405 VPWR VGND sg13g2_decap_8
XFILLER_12_489 VPWR VGND sg13g2_decap_8
XFILLER_12_8 VPWR VGND sg13g2_fill_1
XFILLER_3_165 VPWR VGND sg13g2_decap_8
XFILLER_15_261 VPWR VGND sg13g2_decap_8
XFILLER_35_504 VPWR VGND sg13g2_decap_8
XFILLER_47_364 VPWR VGND sg13g2_decap_8
XFILLER_30_242 VPWR VGND sg13g2_decap_8
XFILLER_31_743 VPWR VGND sg13g2_fill_1
XFILLER_31_798 VPWR VGND sg13g2_fill_1
XFILLER_43_581 VPWR VGND sg13g2_decap_8
X_0704_ _0253_ net56 _0438_ _0439_ VPWR VGND sg13g2_a21o_1
X_0635_ net91 VPWR _0387_ VGND net70 state\[43\] sg13g2_o21ai_1
X_0566_ _0089_ _0334_ _0335_ net37 _0218_ VPWR VGND sg13g2_a22oi_1
XFILLER_26_504 VPWR VGND sg13g2_decap_8
XFILLER_38_364 VPWR VGND sg13g2_decap_8
X_0497_ VGND VPWR net23 daisychain\[7\] _0284_ net37 sg13g2_a21oi_1
XFILLER_21_253 VPWR VGND sg13g2_decap_8
XFILLER_34_581 VPWR VGND sg13g2_decap_8
X_1049_ daisychain\[57\] net16 VPWR VGND sg13g2_buf_1
XFILLER_0_168 VPWR VGND sg13g2_decap_8
XFILLER_17_526 VPWR VGND sg13g2_decap_8
XFILLER_28_53 VPWR VGND sg13g2_decap_8
XFILLER_29_342 VPWR VGND sg13g2_decap_8
XFILLER_32_529 VPWR VGND sg13g2_decap_8
XFILLER_44_30 VPWR VGND sg13g2_fill_1
XFILLER_44_345 VPWR VGND sg13g2_decap_8
XFILLER_12_286 VPWR VGND sg13g2_decap_8
XFILLER_40_540 VPWR VGND sg13g2_decap_8
XFILLER_9_736 VPWR VGND sg13g2_decap_8
XFILLER_8_279 VPWR VGND sg13g2_decap_8
XFILLER_8_202 VPWR VGND sg13g2_decap_8
XFILLER_5_46 VPWR VGND sg13g2_decap_8
XFILLER_4_452 VPWR VGND sg13g2_decap_8
XFILLER_35_301 VPWR VGND sg13g2_decap_8
XFILLER_39_117 VPWR VGND sg13g2_decap_8
XFILLER_47_161 VPWR VGND sg13g2_decap_8
XFILLER_48_651 VPWR VGND sg13g2_decap_8
XFILLER_16_581 VPWR VGND sg13g2_decap_4
XFILLER_31_562 VPWR VGND sg13g2_decap_8
XFILLER_35_378 VPWR VGND sg13g2_decap_8
X_0618_ _0102_ _0373_ _0374_ net52 _0231_ VPWR VGND sg13g2_a22oi_1
X_0549_ VGND VPWR net26 daisychain\[20\] _0323_ net43 sg13g2_a21oi_1
XFILLER_26_301 VPWR VGND sg13g2_decap_8
XFILLER_26_378 VPWR VGND sg13g2_decap_8
XFILLER_38_161 VPWR VGND sg13g2_decap_8
XFILLER_10_735 VPWR VGND sg13g2_decap_8
XFILLER_14_44 VPWR VGND sg13g2_decap_8
XFILLER_22_595 VPWR VGND sg13g2_decap_8
XFILLER_30_32 VPWR VGND sg13g2_decap_8
XFILLER_5_249 VPWR VGND sg13g2_decap_8
XFILLER_1_455 VPWR VGND sg13g2_decap_8
XFILLER_39_96 VPWR VGND sg13g2_decap_8
XFILLER_49_459 VPWR VGND sg13g2_decap_8
XFILLER_13_562 VPWR VGND sg13g2_decap_8
XFILLER_17_323 VPWR VGND sg13g2_decap_8
XFILLER_32_326 VPWR VGND sg13g2_decap_8
XFILLER_44_142 VPWR VGND sg13g2_decap_8
XFILLER_45_654 VPWR VGND sg13g2_fill_1
XFILLER_9_522 VPWR VGND sg13g2_decap_8
XFILLER_23_337 VPWR VGND sg13g2_decap_8
XFILLER_35_175 VPWR VGND sg13g2_decap_8
XFILLER_39_470 VPWR VGND sg13g2_decap_4
XFILLER_14_359 VPWR VGND sg13g2_decap_8
XFILLER_25_65 VPWR VGND sg13g2_decap_8
XFILLER_26_175 VPWR VGND sg13g2_decap_8
XFILLER_27_643 VPWR VGND sg13g2_decap_8
XFILLER_41_112 VPWR VGND sg13g2_decap_8
XFILLER_42_613 VPWR VGND sg13g2_fill_2
Xclkbuf_5_2__f_clk clknet_5_2__leaf_clk clknet_4_1_0_clk VPWR VGND sg13g2_buf_16
XFILLER_10_510 VPWR VGND sg13g2_decap_8
XFILLER_22_392 VPWR VGND sg13g2_decap_8
XFILLER_41_42 VPWR VGND sg13g2_decap_8
XFILLER_1_252 VPWR VGND sg13g2_decap_8
XFILLER_2_25 VPWR VGND sg13g2_decap_8
XFILLER_2_797 VPWR VGND sg13g2_fill_1
XFILLER_17_120 VPWR VGND sg13g2_decap_8
XFILLER_18_665 VPWR VGND sg13g2_decap_8
XFILLER_33_613 VPWR VGND sg13g2_decap_8
XFILLER_45_462 VPWR VGND sg13g2_decap_8
XFILLER_49_256 VPWR VGND sg13g2_decap_8
XFILLER_17_197 VPWR VGND sg13g2_decap_8
XFILLER_20_318 VPWR VGND sg13g2_decap_8
XFILLER_32_123 VPWR VGND sg13g2_decap_8
X_0952_ net114 VGND VPWR _0112_ daisychain\[48\] clknet_5_23__leaf_clk sg13g2_dfrbpq_1
X_0883_ VPWR _0241_ daisychain\[48\] VGND sg13g2_inv_1
XFILLER_9_396 VPWR VGND sg13g2_decap_8
XFILLER_23_134 VPWR VGND sg13g2_decap_8
XFILLER_24_602 VPWR VGND sg13g2_decap_8
XFILLER_24_679 VPWR VGND sg13g2_decap_8
XFILLER_36_462 VPWR VGND sg13g2_decap_8
Xclkbuf_4_2_0_clk clknet_0_clk clknet_4_2_0_clk VPWR VGND sg13g2_buf_8
XFILLER_11_67 VPWR VGND sg13g2_decap_8
XFILLER_27_440 VPWR VGND sg13g2_decap_8
XFILLER_36_42 VPWR VGND sg13g2_decap_8
XFILLER_46_259 VPWR VGND sg13g2_decap_8
XFILLER_47_738 VPWR VGND sg13g2_decap_8
XFILLER_14_156 VPWR VGND sg13g2_decap_8
XFILLER_30_627 VPWR VGND sg13g2_decap_8
XFILLER_42_476 VPWR VGND sg13g2_decap_8
XFILLER_10_384 VPWR VGND sg13g2_decap_8
XFILLER_6_344 VPWR VGND sg13g2_decap_8
XFILLER_2_550 VPWR VGND sg13g2_decap_8
XFILLER_35_7 VPWR VGND sg13g2_decap_8
XFILLER_18_462 VPWR VGND sg13g2_decap_8
XFILLER_33_410 VPWR VGND sg13g2_decap_8
XFILLER_37_259 VPWR VGND sg13g2_decap_8
XFILLER_20_115 VPWR VGND sg13g2_decap_8
XFILLER_21_638 VPWR VGND sg13g2_decap_8
XFILLER_33_487 VPWR VGND sg13g2_decap_8
X_0866_ VPWR _0030_ state\[40\] VGND sg13g2_inv_1
X_0935_ net103 VGND VPWR _0095_ daisychain\[31\] clknet_5_16__leaf_clk sg13g2_dfrbpq_1
XFILLER_9_193 VPWR VGND sg13g2_decap_8
X_0797_ VPWR _0198_ daisychain\[5\] VGND sg13g2_inv_1
XFILLER_29_749 VPWR VGND sg13g2_fill_1
XFILLER_11_137 VPWR VGND sg13g2_decap_8
XFILLER_24_476 VPWR VGND sg13g2_decap_8
XFILLER_37_782 VPWR VGND sg13g2_fill_2
XFILLER_43_229 VPWR VGND sg13g2_decap_8
XFILLER_20_682 VPWR VGND sg13g2_decap_8
XFILLER_22_11 VPWR VGND sg13g2_fill_2
XFILLER_22_77 VPWR VGND sg13g2_decap_8
XFILLER_7_119 VPWR VGND sg13g2_decap_8
XFILLER_3_347 VPWR VGND sg13g2_decap_8
XFILLER_15_443 VPWR VGND sg13g2_decap_8
XFILLER_47_546 VPWR VGND sg13g2_decap_8
XFILLER_47_63 VPWR VGND sg13g2_decap_8
XFILLER_30_424 VPWR VGND sg13g2_decap_8
XFILLER_42_273 VPWR VGND sg13g2_decap_8
X_0720_ _0258_ VPWR _0128_ VGND net78 _0032_ sg13g2_o21ai_1
XFILLER_8_13 VPWR VGND sg13g2_decap_8
XFILLER_7_620 VPWR VGND sg13g2_decap_8
XFILLER_10_181 VPWR VGND sg13g2_decap_8
X_0651_ net94 VPWR _0399_ VGND net73 state\[47\] sg13g2_o21ai_1
X_0582_ _0093_ _0346_ _0347_ net39 _0222_ VPWR VGND sg13g2_a22oi_1
XFILLER_6_141 VPWR VGND sg13g2_decap_8
XFILLER_33_4 VPWR VGND sg13g2_decap_8
XFILLER_38_546 VPWR VGND sg13g2_decap_8
XFILLER_19_793 VPWR VGND sg13g2_fill_1
XFILLER_21_435 VPWR VGND sg13g2_decap_8
XFILLER_33_284 VPWR VGND sg13g2_decap_8
XFILLER_34_796 VPWR VGND sg13g2_fill_2
Xdigitalen.g\[0\].u.inv2 VPWR digitalen.g\[0\].u.OUTP digitalen.g\[0\].u.OUTN VGND
+ sg13g2_inv_1
X_0849_ VPWR _0224_ daisychain\[31\] VGND sg13g2_inv_1
X_0918_ net105 VGND VPWR _0078_ daisychain\[14\] clknet_5_4__leaf_clk sg13g2_dfrbpq_1
XFILLER_16_207 VPWR VGND sg13g2_decap_8
XFILLER_17_99 VPWR VGND sg13g2_decap_8
XFILLER_25_730 VPWR VGND sg13g2_decap_8
XFILLER_29_524 VPWR VGND sg13g2_decap_8
XFILLER_44_549 VPWR VGND sg13g2_decap_8
XFILLER_12_468 VPWR VGND sg13g2_decap_8
XFILLER_24_273 VPWR VGND sg13g2_decap_8
XFILLER_33_32 VPWR VGND sg13g2_decap_8
XFILLER_3_144 VPWR VGND sg13g2_decap_8
XFILLER_47_343 VPWR VGND sg13g2_decap_8
XFILLER_15_240 VPWR VGND sg13g2_decap_8
XFILLER_30_221 VPWR VGND sg13g2_decap_8
XFILLER_31_722 VPWR VGND sg13g2_decap_4
XFILLER_43_560 VPWR VGND sg13g2_decap_8
XFILLER_30_298 VPWR VGND sg13g2_decap_8
X_0703_ net76 VPWR _0438_ VGND net56 state\[60\] sg13g2_o21ai_1
XFILLER_7_483 VPWR VGND sg13g2_decap_8
X_0634_ _0106_ _0385_ _0386_ net50 _0235_ VPWR VGND sg13g2_a22oi_1
X_0565_ VGND VPWR net26 daisychain\[24\] _0335_ net40 sg13g2_a21oi_1
X_0496_ _0201_ net59 _0282_ _0283_ VPWR VGND sg13g2_a21o_1
XFILLER_38_343 VPWR VGND sg13g2_decap_8
XFILLER_0_91 VPWR VGND sg13g2_decap_8
XFILLER_21_232 VPWR VGND sg13g2_decap_8
XFILLER_22_722 VPWR VGND sg13g2_decap_8
XFILLER_22_733 VPWR VGND sg13g2_fill_1
XFILLER_34_560 VPWR VGND sg13g2_decap_8
X_1048_ daisychain\[56\] net15 VPWR VGND sg13g2_buf_1
XFILLER_0_147 VPWR VGND sg13g2_decap_8
XFILLER_28_32 VPWR VGND sg13g2_decap_8
XFILLER_29_321 VPWR VGND sg13g2_decap_8
XFILLER_17_505 VPWR VGND sg13g2_decap_8
XFILLER_25_593 VPWR VGND sg13g2_decap_8
XFILLER_29_398 VPWR VGND sg13g2_decap_8
XFILLER_32_508 VPWR VGND sg13g2_decap_8
XFILLER_44_324 VPWR VGND sg13g2_decap_8
XFILLER_44_86 VPWR VGND sg13g2_decap_8
XFILLER_12_265 VPWR VGND sg13g2_decap_8
XFILLER_40_596 VPWR VGND sg13g2_decap_8
XFILLER_8_258 VPWR VGND sg13g2_decap_8
XFILLER_5_25 VPWR VGND sg13g2_decap_8
XFILLER_4_431 VPWR VGND sg13g2_decap_8
XFILLER_47_140 VPWR VGND sg13g2_decap_8
XFILLER_48_685 VPWR VGND sg13g2_fill_2
XFILLER_48_630 VPWR VGND sg13g2_decap_8
XFILLER_16_560 VPWR VGND sg13g2_decap_8
XFILLER_23_519 VPWR VGND sg13g2_decap_8
XFILLER_31_541 VPWR VGND sg13g2_decap_8
XFILLER_35_357 VPWR VGND sg13g2_decap_8
XFILLER_43_390 VPWR VGND sg13g2_decap_8
XFILLER_7_280 VPWR VGND sg13g2_decap_8
XFILLER_27_803 VPWR VGND sg13g2_decap_8
X_0617_ VGND VPWR net27 daisychain\[37\] _0374_ net47 sg13g2_a21oi_1
X_0548_ _0214_ net64 _0321_ _0322_ VPWR VGND sg13g2_a21o_1
X_0479_ net79 VPWR _0270_ VGND net57 state\[4\] sg13g2_o21ai_1
XFILLER_26_357 VPWR VGND sg13g2_decap_8
XFILLER_38_140 VPWR VGND sg13g2_decap_8
XFILLER_41_349 VPWR VGND sg13g2_decap_8
XFILLER_10_714 VPWR VGND sg13g2_decap_8
XFILLER_22_574 VPWR VGND sg13g2_decap_8
XFILLER_5_228 VPWR VGND sg13g2_decap_8
XFILLER_1_434 VPWR VGND sg13g2_decap_8
XFILLER_30_88 VPWR VGND sg13g2_decap_8
XFILLER_17_302 VPWR VGND sg13g2_decap_8
XFILLER_29_195 VPWR VGND sg13g2_decap_8
XFILLER_39_75 VPWR VGND sg13g2_decap_8
XFILLER_44_121 VPWR VGND sg13g2_decap_8
XFILLER_49_438 VPWR VGND sg13g2_decap_8
XFILLER_13_541 VPWR VGND sg13g2_decap_8
XFILLER_17_379 VPWR VGND sg13g2_decap_8
XFILLER_32_305 VPWR VGND sg13g2_decap_8
XFILLER_44_198 VPWR VGND sg13g2_decap_8
XFILLER_45_699 VPWR VGND sg13g2_decap_4
XFILLER_9_501 VPWR VGND sg13g2_decap_8
XFILLER_40_393 VPWR VGND sg13g2_decap_8
XFILLER_9_578 VPWR VGND sg13g2_fill_2
XFILLER_23_316 VPWR VGND sg13g2_decap_8
XFILLER_24_817 VPWR VGND sg13g2_decap_4
XFILLER_35_154 VPWR VGND sg13g2_decap_8
XFILLER_36_699 VPWR VGND sg13g2_fill_1
XFILLER_27_622 VPWR VGND sg13g2_decap_8
XFILLER_14_338 VPWR VGND sg13g2_decap_8
XFILLER_22_371 VPWR VGND sg13g2_decap_8
XFILLER_25_44 VPWR VGND sg13g2_decap_8
XFILLER_26_154 VPWR VGND sg13g2_decap_8
XFILLER_27_699 VPWR VGND sg13g2_decap_8
XFILLER_41_168 VPWR VGND sg13g2_decap_8
XFILLER_41_179 VPWR VGND sg13g2_fill_1
XFILLER_10_566 VPWR VGND sg13g2_decap_8
XFILLER_10_599 VPWR VGND sg13g2_decap_8
XFILLER_41_98 VPWR VGND sg13g2_decap_8
XFILLER_6_537 VPWR VGND sg13g2_decap_8
XFILLER_1_231 VPWR VGND sg13g2_decap_8
XFILLER_49_235 VPWR VGND sg13g2_decap_8
XFILLER_17_176 VPWR VGND sg13g2_decap_8
XFILLER_18_644 VPWR VGND sg13g2_decap_8
XFILLER_32_102 VPWR VGND sg13g2_decap_8
XFILLER_45_441 VPWR VGND sg13g2_decap_8
XFILLER_32_179 VPWR VGND sg13g2_decap_8
XFILLER_40_190 VPWR VGND sg13g2_decap_8
XFILLER_41_691 VPWR VGND sg13g2_fill_1
X_0882_ VPWR _0007_ state\[48\] VGND sg13g2_inv_1
X_0951_ net112 VGND VPWR _0111_ daisychain\[47\] clknet_5_21__leaf_clk sg13g2_dfrbpq_1
XFILLER_9_375 VPWR VGND sg13g2_decap_8
XFILLER_49_791 VPWR VGND sg13g2_decap_8
XFILLER_11_319 VPWR VGND sg13g2_decap_8
XFILLER_23_113 VPWR VGND sg13g2_decap_8
XFILLER_24_658 VPWR VGND sg13g2_decap_8
XFILLER_36_441 VPWR VGND sg13g2_decap_8
XFILLER_11_46 VPWR VGND sg13g2_decap_8
XFILLER_3_529 VPWR VGND sg13g2_decap_8
XFILLER_15_614 VPWR VGND sg13g2_decap_8
XFILLER_27_496 VPWR VGND sg13g2_decap_8
XFILLER_36_21 VPWR VGND sg13g2_decap_8
XFILLER_46_238 VPWR VGND sg13g2_decap_8
XFILLER_14_135 VPWR VGND sg13g2_decap_8
XFILLER_23_680 VPWR VGND sg13g2_decap_8
XFILLER_30_606 VPWR VGND sg13g2_decap_8
XFILLER_36_98 VPWR VGND sg13g2_decap_8
XFILLER_42_455 VPWR VGND sg13g2_decap_8
XFILLER_10_363 VPWR VGND sg13g2_decap_8
XFILLER_6_323 VPWR VGND sg13g2_decap_8
XFILLER_37_238 VPWR VGND sg13g2_decap_8
XFILLER_18_441 VPWR VGND sg13g2_decap_8
XFILLER_21_617 VPWR VGND sg13g2_decap_8
XFILLER_33_466 VPWR VGND sg13g2_decap_8
XFILLER_14_691 VPWR VGND sg13g2_decap_8
X_0865_ VPWR _0232_ daisychain\[39\] VGND sg13g2_inv_1
X_0934_ net103 VGND VPWR _0094_ daisychain\[30\] clknet_5_9__leaf_clk sg13g2_dfrbpq_1
XFILLER_9_172 VPWR VGND sg13g2_decap_8
X_0796_ VPWR _0059_ state\[5\] VGND sg13g2_inv_1
XFILLER_28_249 VPWR VGND sg13g2_decap_8
XFILLER_29_706 VPWR VGND sg13g2_decap_8
XFILLER_43_208 VPWR VGND sg13g2_decap_8
XFILLER_11_116 VPWR VGND sg13g2_decap_8
XFILLER_20_661 VPWR VGND sg13g2_decap_8
XFILLER_24_455 VPWR VGND sg13g2_decap_8
XFILLER_22_56 VPWR VGND sg13g2_decap_8
XFILLER_3_326 VPWR VGND sg13g2_decap_8
XFILLER_47_42 VPWR VGND sg13g2_decap_8
XFILLER_47_525 VPWR VGND sg13g2_decap_8
XFILLER_15_422 VPWR VGND sg13g2_decap_8
XFILLER_19_249 VPWR VGND sg13g2_decap_8
XFILLER_27_293 VPWR VGND sg13g2_decap_8
XFILLER_28_783 VPWR VGND sg13g2_decap_4
XFILLER_30_403 VPWR VGND sg13g2_decap_8
XFILLER_42_252 VPWR VGND sg13g2_decap_8
XFILLER_10_160 VPWR VGND sg13g2_decap_8
XFILLER_11_683 VPWR VGND sg13g2_fill_2
XFILLER_15_499 VPWR VGND sg13g2_decap_8
XFILLER_8_69 VPWR VGND sg13g2_decap_8
XFILLER_6_120 VPWR VGND sg13g2_decap_8
Xdac0 digitalen.g\[1\].u.OUTP digitalen.g\[1\].u.OUTN digitalen.g\[2\].u.OUTP digitalen.g\[2\].u.OUTN
+ state\[16\] _0039_ state\[17\] _0040_ state\[18\] _0041_ state\[19\] _0042_ state\[20\]
+ _0044_ state\[21\] _0045_ state\[22\] _0046_ state\[23\] _0047_ state\[24\] _0048_
+ state\[25\] _0049_ state\[26\] _0050_ state\[27\] _0051_ state\[28\] _0052_ state\[29\]
+ _0053_ state\[30\] _0055_ state\[31\] _0056_ digitalen.g\[3\].u.OUTP digitalen.g\[3\].u.OUTN
+ state\[0\] _0032_ state\[1\] _0043_ state\[2\] _0054_ state\[3\] _0057_ state\[4\]
+ _0058_ state\[5\] _0059_ state\[6\] digitalen.g\[0\].u.OUTP digitalen.g\[0\].u.OUTN
+ _0060_ state\[7\] _0061_ state\[8\] _0062_ state\[9\] _0063_ state\[10\] _0033_
+ state\[11\] _0034_ state\[12\] _0035_ state\[13\] _0036_ state\[14\] _0037_ state\[15\]
+ _0038_ dac0/Iout dac0/VbiasP[0] dac0/VbiasP[1] dac0/VcascP[1] dac0/VcascP[0] VPWR
+ VGND dac32module
X_0650_ _0110_ _0397_ _0398_ net53 _0239_ VPWR VGND sg13g2_a22oi_1
X_0581_ VGND VPWR net24 daisychain\[28\] _0347_ net39 sg13g2_a21oi_1
XFILLER_6_197 VPWR VGND sg13g2_decap_8
XFILLER_19_772 VPWR VGND sg13g2_decap_8
XFILLER_25_219 VPWR VGND sg13g2_decap_8
XFILLER_26_4 VPWR VGND sg13g2_decap_8
XFILLER_38_525 VPWR VGND sg13g2_decap_8
Xclkbuf_4_1_0_clk clknet_0_clk clknet_4_1_0_clk VPWR VGND sg13g2_buf_8
XFILLER_21_414 VPWR VGND sg13g2_decap_8
XFILLER_33_263 VPWR VGND sg13g2_decap_8
XFILLER_34_753 VPWR VGND sg13g2_fill_1
X_0917_ net104 VGND VPWR _0077_ daisychain\[13\] clknet_5_4__leaf_clk sg13g2_dfrbpq_1
X_0848_ VPWR _0056_ state\[31\] VGND sg13g2_inv_1
X_0779_ _0436_ VPWR _0187_ VGND net76 _0019_ sg13g2_o21ai_1
XFILLER_0_329 VPWR VGND sg13g2_decap_8
XFILLER_29_503 VPWR VGND sg13g2_decap_8
XFILLER_17_78 VPWR VGND sg13g2_decap_8
XFILLER_24_252 VPWR VGND sg13g2_decap_8
XFILLER_44_528 VPWR VGND sg13g2_decap_8
XFILLER_12_447 VPWR VGND sg13g2_decap_8
XFILLER_33_11 VPWR VGND sg13g2_decap_8
XFILLER_33_88 VPWR VGND sg13g2_decap_8
XFILLER_3_123 VPWR VGND sg13g2_decap_8
XFILLER_4_679 VPWR VGND sg13g2_decap_8
XFILLER_35_539 VPWR VGND sg13g2_decap_8
XFILLER_47_322 VPWR VGND sg13g2_decap_8
XFILLER_15_296 VPWR VGND sg13g2_decap_8
XFILLER_30_200 VPWR VGND sg13g2_decap_8
XFILLER_47_399 VPWR VGND sg13g2_decap_8
XFILLER_11_480 VPWR VGND sg13g2_decap_8
XFILLER_30_277 VPWR VGND sg13g2_decap_8
X_0702_ _0123_ _0436_ _0437_ net35 _0252_ VPWR VGND sg13g2_a22oi_1
X_0633_ VGND VPWR net28 daisychain\[41\] _0386_ net51 sg13g2_a21oi_1
XFILLER_7_462 VPWR VGND sg13g2_decap_8
XFILLER_38_322 VPWR VGND sg13g2_decap_8
X_0564_ _0218_ net60 _0333_ _0334_ VPWR VGND sg13g2_a21o_1
X_0495_ net80 VPWR _0282_ VGND net59 state\[8\] sg13g2_o21ai_1
XFILLER_0_70 VPWR VGND sg13g2_decap_8
XFILLER_17_0 VPWR VGND sg13g2_decap_4
XFILLER_26_539 VPWR VGND sg13g2_decap_8
X_1047_ state\[63\] net14 VPWR VGND sg13g2_buf_1
XFILLER_21_211 VPWR VGND sg13g2_decap_8
XFILLER_21_288 VPWR VGND sg13g2_decap_8
XFILLER_0_126 VPWR VGND sg13g2_decap_8
XFILLER_28_11 VPWR VGND sg13g2_decap_8
XFILLER_28_88 VPWR VGND sg13g2_decap_8
XFILLER_29_300 VPWR VGND sg13g2_decap_8
XFILLER_29_377 VPWR VGND sg13g2_decap_8
XFILLER_44_303 VPWR VGND sg13g2_decap_8
XFILLER_48_119 VPWR VGND sg13g2_decap_8
XFILLER_12_244 VPWR VGND sg13g2_decap_8
XFILLER_13_712 VPWR VGND sg13g2_fill_2
XFILLER_25_572 VPWR VGND sg13g2_decap_8
XFILLER_44_21 VPWR VGND sg13g2_fill_2
XFILLER_40_575 VPWR VGND sg13g2_decap_8
XFILLER_8_237 VPWR VGND sg13g2_decap_8
XFILLER_4_410 VPWR VGND sg13g2_decap_8
XFILLER_4_487 VPWR VGND sg13g2_decap_8
XFILLER_0_693 VPWR VGND sg13g2_fill_1
XFILLER_35_336 VPWR VGND sg13g2_decap_8
XFILLER_47_196 VPWR VGND sg13g2_decap_8
XFILLER_31_520 VPWR VGND sg13g2_decap_8
XFILLER_31_597 VPWR VGND sg13g2_decap_8
X_0616_ _0231_ net72 _0372_ _0373_ VPWR VGND sg13g2_a21o_1
X_0547_ net85 VPWR _0321_ VGND net64 state\[21\] sg13g2_o21ai_1
X_0478_ _0067_ _0268_ _0269_ net36 _0196_ VPWR VGND sg13g2_a22oi_1
XFILLER_22_553 VPWR VGND sg13g2_decap_8
XFILLER_26_336 VPWR VGND sg13g2_decap_8
XFILLER_38_196 VPWR VGND sg13g2_decap_8
XFILLER_41_328 VPWR VGND sg13g2_decap_8
XFILLER_14_79 VPWR VGND sg13g2_decap_8
XFILLER_6_708 VPWR VGND sg13g2_fill_2
XFILLER_5_207 VPWR VGND sg13g2_decap_8
XFILLER_1_413 VPWR VGND sg13g2_decap_8
XFILLER_30_67 VPWR VGND sg13g2_decap_8
XFILLER_39_54 VPWR VGND sg13g2_decap_8
XFILLER_49_417 VPWR VGND sg13g2_decap_8
XFILLER_17_358 VPWR VGND sg13g2_decap_8
XFILLER_29_174 VPWR VGND sg13g2_decap_8
XFILLER_44_100 VPWR VGND sg13g2_decap_8
XFILLER_45_678 VPWR VGND sg13g2_fill_2
XFILLER_13_520 VPWR VGND sg13g2_decap_8
XFILLER_13_597 VPWR VGND sg13g2_decap_8
XFILLER_25_380 VPWR VGND sg13g2_decap_8
XFILLER_40_372 VPWR VGND sg13g2_decap_8
XFILLER_44_177 VPWR VGND sg13g2_decap_8
XFILLER_9_557 VPWR VGND sg13g2_decap_8
XFILLER_4_284 VPWR VGND sg13g2_decap_8
XFILLER_0_490 VPWR VGND sg13g2_decap_8
Xclkbuf_5_27__f_clk clknet_5_27__leaf_clk clknet_4_13_0_clk VPWR VGND sg13g2_buf_16
XFILLER_35_133 VPWR VGND sg13g2_decap_8
XFILLER_36_623 VPWR VGND sg13g2_decap_8
XFILLER_48_483 VPWR VGND sg13g2_decap_8
XFILLER_31_394 VPWR VGND sg13g2_decap_8
XFILLER_15_818 VPWR VGND sg13g2_decap_4
XFILLER_26_133 VPWR VGND sg13g2_decap_8
XFILLER_27_601 VPWR VGND sg13g2_decap_8
XFILLER_27_678 VPWR VGND sg13g2_decap_8
XFILLER_14_317 VPWR VGND sg13g2_decap_8
XFILLER_22_350 VPWR VGND sg13g2_decap_8
XFILLER_41_147 VPWR VGND sg13g2_decap_8
XFILLER_10_545 VPWR VGND sg13g2_decap_8
XFILLER_1_210 VPWR VGND sg13g2_decap_8
XFILLER_41_77 VPWR VGND sg13g2_decap_8
XFILLER_6_505 VPWR VGND sg13g2_decap_8
XFILLER_1_287 VPWR VGND sg13g2_decap_8
XFILLER_2_788 VPWR VGND sg13g2_fill_2
XFILLER_49_214 VPWR VGND sg13g2_decap_8
XFILLER_17_155 VPWR VGND sg13g2_decap_8
XFILLER_18_623 VPWR VGND sg13g2_decap_8
XFILLER_33_648 VPWR VGND sg13g2_decap_8
XFILLER_45_420 VPWR VGND sg13g2_decap_8
XFILLER_45_497 VPWR VGND sg13g2_decap_8
XFILLER_13_394 VPWR VGND sg13g2_decap_8
XFILLER_32_158 VPWR VGND sg13g2_decap_8
X_0881_ VPWR _0240_ daisychain\[47\] VGND sg13g2_inv_1
X_0950_ net112 VGND VPWR _0110_ daisychain\[46\] clknet_5_19__leaf_clk sg13g2_dfrbpq_1
XFILLER_9_354 VPWR VGND sg13g2_decap_8
XFILLER_36_420 VPWR VGND sg13g2_decap_8
XFILLER_48_280 VPWR VGND sg13g2_decap_8
XFILLER_23_169 VPWR VGND sg13g2_decap_8
XFILLER_24_637 VPWR VGND sg13g2_decap_8
XFILLER_36_497 VPWR VGND sg13g2_decap_8
XFILLER_11_25 VPWR VGND sg13g2_decap_8
XFILLER_31_191 VPWR VGND sg13g2_decap_8
XFILLER_3_508 VPWR VGND sg13g2_decap_8
Xclkbuf_5_10__f_clk clknet_5_10__leaf_clk clknet_4_5_0_clk VPWR VGND sg13g2_buf_16
XFILLER_14_114 VPWR VGND sg13g2_decap_8
XFILLER_27_475 VPWR VGND sg13g2_decap_8
XFILLER_36_77 VPWR VGND sg13g2_decap_8
XFILLER_42_434 VPWR VGND sg13g2_decap_8
XFILLER_46_217 VPWR VGND sg13g2_decap_8
XFILLER_10_342 VPWR VGND sg13g2_decap_8
XFILLER_6_302 VPWR VGND sg13g2_decap_8
XFILLER_6_379 VPWR VGND sg13g2_decap_8
XFILLER_18_420 VPWR VGND sg13g2_decap_8
XFILLER_37_217 VPWR VGND sg13g2_decap_8
XFILLER_18_497 VPWR VGND sg13g2_decap_8
XFILLER_33_445 VPWR VGND sg13g2_decap_8
XFILLER_45_294 VPWR VGND sg13g2_decap_8
XFILLER_13_191 VPWR VGND sg13g2_decap_8
X_0864_ VPWR _0029_ state\[39\] VGND sg13g2_inv_1
X_0933_ net103 VGND VPWR _0093_ daisychain\[29\] clknet_5_9__leaf_clk sg13g2_dfrbpq_1
X_0795_ VPWR _0197_ daisychain\[4\] VGND sg13g2_inv_1
XFILLER_9_151 VPWR VGND sg13g2_decap_8
XFILLER_3_81 VPWR VGND sg13g2_decap_8
XFILLER_47_0 VPWR VGND sg13g2_decap_8
XFILLER_24_434 VPWR VGND sg13g2_decap_8
XFILLER_28_228 VPWR VGND sg13g2_decap_8
XFILLER_36_294 VPWR VGND sg13g2_decap_8
XFILLER_20_640 VPWR VGND sg13g2_decap_8
XFILLER_22_35 VPWR VGND sg13g2_decap_8
XFILLER_3_305 VPWR VGND sg13g2_decap_8
XFILLER_19_228 VPWR VGND sg13g2_decap_8
XFILLER_47_21 VPWR VGND sg13g2_decap_8
XFILLER_47_504 VPWR VGND sg13g2_decap_8
XFILLER_47_98 VPWR VGND sg13g2_decap_8
XFILLER_15_401 VPWR VGND sg13g2_decap_8
XFILLER_15_478 VPWR VGND sg13g2_decap_8
XFILLER_27_272 VPWR VGND sg13g2_decap_8
XFILLER_28_762 VPWR VGND sg13g2_decap_8
XFILLER_42_231 VPWR VGND sg13g2_decap_8
XFILLER_43_710 VPWR VGND sg13g2_fill_2
XFILLER_43_743 VPWR VGND sg13g2_fill_1
XFILLER_12_90 VPWR VGND sg13g2_decap_8
XFILLER_30_459 VPWR VGND sg13g2_decap_8
Xdac1 digitalen.g\[1\].u.OUTP digitalen.g\[1\].u.OUTN digitalen.g\[2\].u.OUTP digitalen.g\[2\].u.OUTN
+ state\[48\] _0007_ state\[49\] _0008_ state\[50\] _0009_ state\[51\] _0010_ state\[52\]
+ _0012_ state\[53\] _0013_ state\[54\] _0014_ state\[55\] _0015_ state\[56\] _0016_
+ state\[57\] _0017_ state\[58\] _0018_ state\[59\] _0019_ state\[60\] _0020_ state\[61\]
+ _0021_ state\[62\] _0023_ state\[63\] _0024_ digitalen.g\[3\].u.OUTP digitalen.g\[3\].u.OUTN
+ state\[32\] _0000_ state\[33\] _0011_ state\[34\] _0022_ state\[35\] _0025_ state\[36\]
+ _0026_ state\[37\] _0027_ state\[38\] digitalen.g\[0\].u.OUTP digitalen.g\[0\].u.OUTN
+ _0028_ state\[39\] _0029_ state\[40\] _0030_ state\[41\] _0031_ state\[42\] _0001_
+ state\[43\] _0002_ state\[44\] _0003_ state\[45\] _0004_ state\[46\] _0005_ state\[47\]
+ _0006_ dac1/Iout dac1/VbiasP[0] dac1/VbiasP[1] dac1/VcascP[1] dac1/VcascP[0] VPWR
+ VGND dac32module
XFILLER_8_48 VPWR VGND sg13g2_decap_8
XFILLER_6_176 VPWR VGND sg13g2_decap_8
XFILLER_2_382 VPWR VGND sg13g2_decap_8
XFILLER_38_504 VPWR VGND sg13g2_decap_8
X_0580_ _0222_ net60 _0345_ _0346_ VPWR VGND sg13g2_a21o_1
XFILLER_18_294 VPWR VGND sg13g2_decap_8
XFILLER_19_4 VPWR VGND sg13g2_decap_4
XFILLER_46_581 VPWR VGND sg13g2_decap_8
XFILLER_33_242 VPWR VGND sg13g2_decap_8
XFILLER_34_798 VPWR VGND sg13g2_fill_1
X_0916_ net104 VGND VPWR _0076_ daisychain\[12\] clknet_5_5__leaf_clk sg13g2_dfrbpq_1
XFILLER_0_308 VPWR VGND sg13g2_decap_8
X_0847_ VPWR _0223_ daisychain\[30\] VGND sg13g2_inv_1
X_0778_ _0433_ VPWR _0186_ VGND net76 _0018_ sg13g2_o21ai_1
XFILLER_17_13 VPWR VGND sg13g2_decap_4
XFILLER_29_559 VPWR VGND sg13g2_decap_8
XFILLER_12_426 VPWR VGND sg13g2_decap_8
XFILLER_17_57 VPWR VGND sg13g2_decap_8
XFILLER_24_231 VPWR VGND sg13g2_decap_8
XFILLER_37_581 VPWR VGND sg13g2_decap_8
XFILLER_40_702 VPWR VGND sg13g2_fill_2
XFILLER_44_507 VPWR VGND sg13g2_decap_8
XFILLER_33_67 VPWR VGND sg13g2_decap_8
XFILLER_3_102 VPWR VGND sg13g2_decap_8
XFILLER_8_419 VPWR VGND sg13g2_decap_8
XFILLER_3_179 VPWR VGND sg13g2_decap_8
Xclkbuf_5_8__f_clk clknet_5_8__leaf_clk clknet_4_4_0_clk VPWR VGND sg13g2_buf_16
XFILLER_4_636 VPWR VGND sg13g2_fill_2
XFILLER_28_592 VPWR VGND sg13g2_decap_8
XFILLER_35_518 VPWR VGND sg13g2_decap_8
XFILLER_47_301 VPWR VGND sg13g2_decap_8
XFILLER_47_378 VPWR VGND sg13g2_decap_8
XFILLER_15_275 VPWR VGND sg13g2_decap_8
XFILLER_16_765 VPWR VGND sg13g2_decap_8
XFILLER_16_776 VPWR VGND sg13g2_fill_1
XFILLER_30_256 VPWR VGND sg13g2_decap_8
XFILLER_43_595 VPWR VGND sg13g2_fill_1
X_0701_ VGND VPWR net33 daisychain\[58\] _0437_ net35 sg13g2_a21oi_1
X_0632_ _0235_ net70 _0384_ _0385_ VPWR VGND sg13g2_a21o_1
X_0563_ net80 VPWR _0333_ VGND net60 state\[25\] sg13g2_o21ai_1
XFILLER_7_441 VPWR VGND sg13g2_decap_8
XFILLER_38_301 VPWR VGND sg13g2_decap_8
X_0494_ _0071_ _0280_ _0281_ net38 _0200_ VPWR VGND sg13g2_a22oi_1
XFILLER_19_592 VPWR VGND sg13g2_decap_8
XFILLER_26_518 VPWR VGND sg13g2_decap_8
XFILLER_34_595 VPWR VGND sg13g2_decap_8
XFILLER_38_378 VPWR VGND sg13g2_fill_2
X_1046_ state\[62\] net13 VPWR VGND sg13g2_buf_1
XFILLER_21_267 VPWR VGND sg13g2_decap_8
XFILLER_0_105 VPWR VGND sg13g2_decap_8
XFILLER_28_67 VPWR VGND sg13g2_decap_8
XFILLER_29_356 VPWR VGND sg13g2_decap_8
XFILLER_12_223 VPWR VGND sg13g2_decap_8
XFILLER_25_551 VPWR VGND sg13g2_decap_8
XFILLER_40_554 VPWR VGND sg13g2_decap_8
XFILLER_44_359 VPWR VGND sg13g2_decap_8
XFILLER_8_216 VPWR VGND sg13g2_decap_8
Xclkbuf_4_0_0_clk clknet_0_clk clknet_4_0_0_clk VPWR VGND sg13g2_buf_8
XFILLER_4_466 VPWR VGND sg13g2_decap_8
XFILLER_0_672 VPWR VGND sg13g2_decap_8
XFILLER_10_8 VPWR VGND sg13g2_fill_1
XFILLER_35_315 VPWR VGND sg13g2_decap_8
XFILLER_36_805 VPWR VGND sg13g2_fill_2
XFILLER_47_175 VPWR VGND sg13g2_decap_8
XFILLER_31_576 VPWR VGND sg13g2_decap_8
X_0615_ net93 VPWR _0372_ VGND net72 state\[38\] sg13g2_o21ai_1
X_0546_ _0084_ _0319_ _0320_ net43 _0213_ VPWR VGND sg13g2_a22oi_1
XFILLER_26_315 VPWR VGND sg13g2_decap_8
XFILLER_38_175 VPWR VGND sg13g2_decap_8
X_0477_ VGND VPWR net32 daisychain\[2\] _0269_ net36 sg13g2_a21oi_1
XFILLER_14_58 VPWR VGND sg13g2_decap_8
XFILLER_22_532 VPWR VGND sg13g2_decap_8
XFILLER_34_392 VPWR VGND sg13g2_decap_8
XFILLER_41_307 VPWR VGND sg13g2_decap_8
X_1029_ net97 VGND VPWR _0189_ state\[61\] clknet_5_10__leaf_clk sg13g2_dfrbpq_1
XFILLER_30_46 VPWR VGND sg13g2_decap_8
XFILLER_1_469 VPWR VGND sg13g2_decap_8
XFILLER_17_337 VPWR VGND sg13g2_decap_8
XFILLER_29_153 VPWR VGND sg13g2_decap_8
XFILLER_33_808 VPWR VGND sg13g2_decap_8
XFILLER_44_156 VPWR VGND sg13g2_decap_8
XFILLER_45_668 VPWR VGND sg13g2_fill_2
XFILLER_13_576 VPWR VGND sg13g2_decap_8
XFILLER_40_351 VPWR VGND sg13g2_decap_8
XFILLER_9_536 VPWR VGND sg13g2_decap_8
XFILLER_4_263 VPWR VGND sg13g2_decap_8
XFILLER_35_112 VPWR VGND sg13g2_decap_8
XFILLER_36_602 VPWR VGND sg13g2_decap_8
XFILLER_48_462 VPWR VGND sg13g2_decap_8
XFILLER_35_189 VPWR VGND sg13g2_decap_8
XFILLER_44_690 VPWR VGND sg13g2_decap_4
XFILLER_31_373 VPWR VGND sg13g2_decap_8
XFILLER_8_580 VPWR VGND sg13g2_decap_8
X_0529_ VGND VPWR net25 daisychain\[15\] _0308_ net42 sg13g2_a21oi_1
XFILLER_6_92 VPWR VGND sg13g2_decap_8
XFILLER_26_112 VPWR VGND sg13g2_decap_8
XFILLER_26_189 VPWR VGND sg13g2_decap_8
XFILLER_27_657 VPWR VGND sg13g2_decap_8
XFILLER_10_524 VPWR VGND sg13g2_decap_8
XFILLER_25_79 VPWR VGND sg13g2_decap_8
XFILLER_35_690 VPWR VGND sg13g2_decap_4
XFILLER_41_126 VPWR VGND sg13g2_decap_8
XFILLER_41_56 VPWR VGND sg13g2_decap_8
XFILLER_42_649 VPWR VGND sg13g2_fill_2
XFILLER_18_602 VPWR VGND sg13g2_decap_8
XFILLER_1_266 VPWR VGND sg13g2_decap_8
XFILLER_2_39 VPWR VGND sg13g2_decap_8
XFILLER_17_134 VPWR VGND sg13g2_decap_8
XFILLER_18_679 VPWR VGND sg13g2_decap_8
XFILLER_32_137 VPWR VGND sg13g2_decap_8
XFILLER_33_627 VPWR VGND sg13g2_decap_8
XFILLER_45_476 VPWR VGND sg13g2_decap_8
XFILLER_13_373 VPWR VGND sg13g2_decap_8
X_0880_ VPWR _0006_ state\[47\] VGND sg13g2_inv_1
XFILLER_9_333 VPWR VGND sg13g2_decap_8
XFILLER_49_4 VPWR VGND sg13g2_decap_8
XFILLER_24_616 VPWR VGND sg13g2_decap_8
XFILLER_36_476 VPWR VGND sg13g2_decap_8
XFILLER_49_771 VPWR VGND sg13g2_decap_8
XFILLER_23_148 VPWR VGND sg13g2_decap_8
XFILLER_31_170 VPWR VGND sg13g2_decap_8
XFILLER_32_693 VPWR VGND sg13g2_fill_1
Xdigitalen.g\[3\].u.inv1 VPWR digitalen.g\[3\].u.OUTN net6 VGND sg13g2_inv_1
XFILLER_27_454 VPWR VGND sg13g2_decap_8
XFILLER_36_56 VPWR VGND sg13g2_decap_8
XFILLER_39_292 VPWR VGND sg13g2_decap_8
XFILLER_42_413 VPWR VGND sg13g2_decap_8
XFILLER_10_321 VPWR VGND sg13g2_decap_8
XFILLER_10_398 VPWR VGND sg13g2_decap_8
XFILLER_6_358 VPWR VGND sg13g2_decap_8
XFILLER_2_564 VPWR VGND sg13g2_decap_4
XFILLER_7_0 VPWR VGND sg13g2_decap_8
XFILLER_18_476 VPWR VGND sg13g2_decap_8
XFILLER_13_170 VPWR VGND sg13g2_decap_8
XFILLER_20_129 VPWR VGND sg13g2_decap_8
XFILLER_33_424 VPWR VGND sg13g2_decap_8
XFILLER_45_273 VPWR VGND sg13g2_decap_8
X_0932_ net103 VGND VPWR _0092_ daisychain\[28\] clknet_5_11__leaf_clk sg13g2_dfrbpq_1
XFILLER_9_130 VPWR VGND sg13g2_decap_8
X_0863_ VPWR _0231_ daisychain\[38\] VGND sg13g2_inv_1
X_0794_ VPWR _0058_ state\[4\] VGND sg13g2_inv_1
XFILLER_28_207 VPWR VGND sg13g2_decap_8
XFILLER_3_60 VPWR VGND sg13g2_decap_8
XFILLER_24_413 VPWR VGND sg13g2_decap_8
XFILLER_36_273 VPWR VGND sg13g2_decap_8
XFILLER_20_696 VPWR VGND sg13g2_fill_2
XFILLER_0_7 VPWR VGND sg13g2_decap_8
XFILLER_19_207 VPWR VGND sg13g2_decap_8
XFILLER_27_251 VPWR VGND sg13g2_decap_8
XFILLER_47_77 VPWR VGND sg13g2_decap_8
XFILLER_15_457 VPWR VGND sg13g2_decap_8
XFILLER_30_438 VPWR VGND sg13g2_decap_8
XFILLER_42_210 VPWR VGND sg13g2_decap_8
XFILLER_42_287 VPWR VGND sg13g2_decap_8
XFILLER_8_27 VPWR VGND sg13g2_decap_8
XFILLER_10_195 VPWR VGND sg13g2_decap_8
XFILLER_11_685 VPWR VGND sg13g2_fill_1
XFILLER_7_645 VPWR VGND sg13g2_fill_1
XFILLER_7_634 VPWR VGND sg13g2_fill_2
XFILLER_6_155 VPWR VGND sg13g2_decap_8
XFILLER_2_361 VPWR VGND sg13g2_decap_8
XFILLER_18_273 VPWR VGND sg13g2_decap_8
XFILLER_19_763 VPWR VGND sg13g2_decap_4
XFILLER_33_221 VPWR VGND sg13g2_decap_8
XFILLER_46_560 VPWR VGND sg13g2_decap_8
XFILLER_21_449 VPWR VGND sg13g2_decap_8
XFILLER_33_298 VPWR VGND sg13g2_decap_8
X_0915_ net101 VGND VPWR _0075_ daisychain\[11\] clknet_5_4__leaf_clk sg13g2_dfrbpq_1
X_0846_ VPWR _0055_ state\[30\] VGND sg13g2_inv_1
X_0777_ _0430_ VPWR _0185_ VGND net96 _0017_ sg13g2_o21ai_1
XFILLER_17_36 VPWR VGND sg13g2_decap_8
XFILLER_29_538 VPWR VGND sg13g2_decap_8
XFILLER_37_560 VPWR VGND sg13g2_decap_8
XFILLER_12_405 VPWR VGND sg13g2_decap_8
XFILLER_24_210 VPWR VGND sg13g2_decap_8
XFILLER_24_287 VPWR VGND sg13g2_decap_8
XFILLER_33_46 VPWR VGND sg13g2_decap_8
XFILLER_20_493 VPWR VGND sg13g2_decap_8
XFILLER_3_158 VPWR VGND sg13g2_decap_8
XFILLER_28_571 VPWR VGND sg13g2_decap_8
XFILLER_47_357 VPWR VGND sg13g2_decap_8
XFILLER_15_254 VPWR VGND sg13g2_decap_8
XFILLER_30_235 VPWR VGND sg13g2_decap_8
XFILLER_43_574 VPWR VGND sg13g2_decap_8
X_0700_ _0252_ net56 _0435_ _0436_ VPWR VGND sg13g2_a21o_1
XFILLER_7_420 VPWR VGND sg13g2_decap_8
X_0631_ net91 VPWR _0384_ VGND net70 state\[42\] sg13g2_o21ai_1
X_0562_ _0088_ _0331_ _0332_ net41 _0217_ VPWR VGND sg13g2_a22oi_1
XFILLER_7_497 VPWR VGND sg13g2_decap_8
XFILLER_31_4 VPWR VGND sg13g2_decap_8
XFILLER_38_357 VPWR VGND sg13g2_decap_8
X_0493_ VGND VPWR net23 daisychain\[6\] _0281_ net38 sg13g2_a21oi_1
XFILLER_19_571 VPWR VGND sg13g2_decap_8
XFILLER_21_246 VPWR VGND sg13g2_decap_8
XFILLER_34_574 VPWR VGND sg13g2_decap_8
X_1045_ state\[61\] net12 VPWR VGND sg13g2_buf_1
X_0829_ VPWR _0214_ daisychain\[21\] VGND sg13g2_inv_1
XFILLER_9_81 VPWR VGND sg13g2_decap_8
XFILLER_17_519 VPWR VGND sg13g2_decap_8
XFILLER_25_530 VPWR VGND sg13g2_decap_8
XFILLER_28_46 VPWR VGND sg13g2_decap_8
XFILLER_29_335 VPWR VGND sg13g2_decap_8
XFILLER_44_338 VPWR VGND sg13g2_decap_8
XFILLER_12_202 VPWR VGND sg13g2_decap_8
XFILLER_12_279 VPWR VGND sg13g2_decap_8
XFILLER_21_780 VPWR VGND sg13g2_decap_8
XFILLER_40_533 VPWR VGND sg13g2_decap_8
XFILLER_9_729 VPWR VGND sg13g2_decap_8
XFILLER_20_290 VPWR VGND sg13g2_decap_8
XFILLER_5_39 VPWR VGND sg13g2_decap_8
XFILLER_4_445 VPWR VGND sg13g2_decap_8
XFILLER_0_640 VPWR VGND sg13g2_fill_2
XFILLER_47_154 VPWR VGND sg13g2_decap_8
XFILLER_48_644 VPWR VGND sg13g2_decap_8
XFILLER_16_530 VPWR VGND sg13g2_decap_8
XFILLER_16_574 VPWR VGND sg13g2_decap_8
XFILLER_16_585 VPWR VGND sg13g2_fill_1
XFILLER_31_555 VPWR VGND sg13g2_decap_8
XFILLER_39_611 VPWR VGND sg13g2_decap_4
X_0614_ _0101_ _0370_ _0371_ net47 _0230_ VPWR VGND sg13g2_a22oi_1
X_0545_ VGND VPWR net31 daisychain\[19\] _0320_ net43 sg13g2_a21oi_1
X_0476_ _0196_ net75 _0267_ _0268_ VPWR VGND sg13g2_a21o_1
XFILLER_7_294 VPWR VGND sg13g2_decap_8
XFILLER_27_817 VPWR VGND sg13g2_decap_4
XFILLER_38_154 VPWR VGND sg13g2_decap_8
XFILLER_10_706 VPWR VGND sg13g2_decap_4
XFILLER_10_728 VPWR VGND sg13g2_decap_8
XFILLER_14_37 VPWR VGND sg13g2_decap_8
XFILLER_22_511 VPWR VGND sg13g2_decap_8
XFILLER_22_588 VPWR VGND sg13g2_decap_8
XFILLER_34_371 VPWR VGND sg13g2_decap_8
X_1028_ net98 VGND VPWR _0188_ state\[60\] clknet_5_26__leaf_clk sg13g2_dfrbpq_1
XFILLER_30_25 VPWR VGND sg13g2_decap_8
XFILLER_1_448 VPWR VGND sg13g2_decap_8
XFILLER_29_132 VPWR VGND sg13g2_decap_8
XFILLER_39_89 VPWR VGND sg13g2_decap_8
XFILLER_45_603 VPWR VGND sg13g2_decap_4
XFILLER_17_316 VPWR VGND sg13g2_decap_8
XFILLER_32_319 VPWR VGND sg13g2_decap_8
XFILLER_44_135 VPWR VGND sg13g2_decap_8
XFILLER_13_555 VPWR VGND sg13g2_decap_8
XFILLER_40_330 VPWR VGND sg13g2_decap_8
XFILLER_9_515 VPWR VGND sg13g2_decap_8
XFILLER_20_80 VPWR VGND sg13g2_decap_8
XFILLER_4_242 VPWR VGND sg13g2_decap_8
XFILLER_48_441 VPWR VGND sg13g2_decap_8
XFILLER_16_382 VPWR VGND sg13g2_decap_8
XFILLER_31_352 VPWR VGND sg13g2_decap_8
XFILLER_35_168 VPWR VGND sg13g2_decap_8
XFILLER_6_71 VPWR VGND sg13g2_decap_8
X_0528_ _0209_ net63 _0306_ _0307_ VPWR VGND sg13g2_a21o_1
X_0459_ VPWR _0255_ daisychain\[62\] VGND sg13g2_inv_1
XFILLER_25_58 VPWR VGND sg13g2_decap_8
XFILLER_26_168 VPWR VGND sg13g2_decap_8
XFILLER_27_636 VPWR VGND sg13g2_decap_8
XFILLER_39_463 VPWR VGND sg13g2_decap_8
XFILLER_39_474 VPWR VGND sg13g2_fill_2
XFILLER_39_496 VPWR VGND sg13g2_decap_8
XFILLER_41_105 VPWR VGND sg13g2_decap_8
XFILLER_10_503 VPWR VGND sg13g2_decap_8
XFILLER_22_385 VPWR VGND sg13g2_decap_8
XFILLER_41_35 VPWR VGND sg13g2_decap_8
XFILLER_1_245 VPWR VGND sg13g2_decap_8
XFILLER_9_4 VPWR VGND sg13g2_decap_8
XFILLER_17_113 VPWR VGND sg13g2_decap_8
XFILLER_18_658 VPWR VGND sg13g2_decap_8
XFILLER_2_18 VPWR VGND sg13g2_decap_8
XFILLER_45_455 VPWR VGND sg13g2_decap_8
XFILLER_49_249 VPWR VGND sg13g2_decap_8
XFILLER_13_352 VPWR VGND sg13g2_decap_8
XFILLER_32_116 VPWR VGND sg13g2_decap_8
XFILLER_33_606 VPWR VGND sg13g2_decap_8
XFILLER_9_312 VPWR VGND sg13g2_decap_8
XFILLER_9_389 VPWR VGND sg13g2_decap_8
XFILLER_23_127 VPWR VGND sg13g2_decap_8
XFILLER_36_455 VPWR VGND sg13g2_decap_8
XFILLER_20_812 VPWR VGND sg13g2_decap_8
XFILLER_32_683 VPWR VGND sg13g2_decap_4
Xdigitalen.g\[3\].u.inv2 VPWR digitalen.g\[3\].u.OUTP digitalen.g\[3\].u.OUTN VGND
+ sg13g2_inv_1
XFILLER_27_433 VPWR VGND sg13g2_decap_8
XFILLER_36_35 VPWR VGND sg13g2_decap_8
XFILLER_39_271 VPWR VGND sg13g2_decap_8
XFILLER_10_300 VPWR VGND sg13g2_decap_8
XFILLER_14_149 VPWR VGND sg13g2_decap_8
XFILLER_15_628 VPWR VGND sg13g2_fill_1
XFILLER_23_694 VPWR VGND sg13g2_decap_8
XFILLER_42_469 VPWR VGND sg13g2_decap_8
XFILLER_10_377 VPWR VGND sg13g2_decap_8
XFILLER_22_182 VPWR VGND sg13g2_decap_8
XFILLER_6_337 VPWR VGND sg13g2_decap_8
XFILLER_2_543 VPWR VGND sg13g2_decap_8
XFILLER_18_455 VPWR VGND sg13g2_decap_8
XFILLER_33_403 VPWR VGND sg13g2_decap_8
XFILLER_45_252 VPWR VGND sg13g2_decap_8
XFILLER_14_661 VPWR VGND sg13g2_decap_8
XFILLER_20_108 VPWR VGND sg13g2_decap_8
X_0862_ VPWR _0028_ state\[38\] VGND sg13g2_inv_1
X_0931_ net103 VGND VPWR _0091_ daisychain\[27\] clknet_5_11__leaf_clk sg13g2_dfrbpq_1
X_0793_ VPWR _0196_ daisychain\[3\] VGND sg13g2_inv_1
XFILLER_9_186 VPWR VGND sg13g2_decap_8
XFILLER_37_720 VPWR VGND sg13g2_fill_2
XFILLER_37_742 VPWR VGND sg13g2_fill_2
XFILLER_24_469 VPWR VGND sg13g2_decap_8
XFILLER_36_252 VPWR VGND sg13g2_decap_8
XFILLER_20_675 VPWR VGND sg13g2_decap_8
XFILLER_32_480 VPWR VGND sg13g2_decap_8
Xfanout110 net111 net110 VPWR VGND sg13g2_buf_1
XFILLER_15_436 VPWR VGND sg13g2_decap_8
XFILLER_27_230 VPWR VGND sg13g2_decap_8
XFILLER_43_712 VPWR VGND sg13g2_fill_1
XFILLER_47_539 VPWR VGND sg13g2_decap_8
XFILLER_47_56 VPWR VGND sg13g2_decap_8
XFILLER_23_491 VPWR VGND sg13g2_decap_8
XFILLER_30_417 VPWR VGND sg13g2_decap_8
XFILLER_42_266 VPWR VGND sg13g2_decap_8
XFILLER_10_174 VPWR VGND sg13g2_decap_8
XFILLER_2_340 VPWR VGND sg13g2_decap_8
XFILLER_6_134 VPWR VGND sg13g2_decap_8
XFILLER_38_539 VPWR VGND sg13g2_decap_8
XFILLER_18_252 VPWR VGND sg13g2_decap_8
XFILLER_19_786 VPWR VGND sg13g2_fill_1
XFILLER_21_428 VPWR VGND sg13g2_decap_8
XFILLER_33_200 VPWR VGND sg13g2_decap_8
XFILLER_33_277 VPWR VGND sg13g2_decap_8
X_0914_ net101 VGND VPWR _0074_ daisychain\[10\] clknet_5_6__leaf_clk sg13g2_dfrbpq_1
X_0845_ VPWR _0222_ daisychain\[29\] VGND sg13g2_inv_1
X_0776_ _0427_ VPWR _0184_ VGND net89 _0016_ sg13g2_o21ai_1
XFILLER_25_723 VPWR VGND sg13g2_decap_8
XFILLER_29_517 VPWR VGND sg13g2_decap_8
XFILLER_24_266 VPWR VGND sg13g2_decap_8
XFILLER_33_25 VPWR VGND sg13g2_decap_8
XFILLER_20_472 VPWR VGND sg13g2_decap_8
XFILLER_3_137 VPWR VGND sg13g2_decap_8
XFILLER_4_638 VPWR VGND sg13g2_fill_1
XFILLER_47_336 VPWR VGND sg13g2_decap_8
XFILLER_15_233 VPWR VGND sg13g2_decap_8
XFILLER_16_701 VPWR VGND sg13g2_fill_1
XFILLER_16_712 VPWR VGND sg13g2_decap_4
XFILLER_28_550 VPWR VGND sg13g2_decap_8
XFILLER_43_553 VPWR VGND sg13g2_decap_8
XFILLER_11_494 VPWR VGND sg13g2_decap_8
XFILLER_30_214 VPWR VGND sg13g2_decap_8
XFILLER_7_476 VPWR VGND sg13g2_decap_8
X_0630_ _0105_ _0382_ _0383_ net51 _0234_ VPWR VGND sg13g2_a22oi_1
X_0561_ VGND VPWR net25 daisychain\[23\] _0332_ net41 sg13g2_a21oi_1
X_0492_ _0200_ net57 _0279_ _0280_ VPWR VGND sg13g2_a21o_1
XFILLER_19_550 VPWR VGND sg13g2_decap_8
XFILLER_24_4 VPWR VGND sg13g2_decap_4
XFILLER_38_336 VPWR VGND sg13g2_decap_8
X_1044_ state\[60\] net11 VPWR VGND sg13g2_buf_1
XFILLER_0_84 VPWR VGND sg13g2_decap_8
XFILLER_21_225 VPWR VGND sg13g2_decap_8
XFILLER_34_553 VPWR VGND sg13g2_decap_8
XFILLER_9_60 VPWR VGND sg13g2_decap_8
X_0828_ VPWR _0045_ state\[21\] VGND sg13g2_inv_1
X_0759_ _0376_ VPWR _0167_ VGND net93 _0029_ sg13g2_o21ai_1
XFILLER_28_25 VPWR VGND sg13g2_decap_8
XFILLER_29_314 VPWR VGND sg13g2_decap_8
XFILLER_25_586 VPWR VGND sg13g2_decap_8
XFILLER_44_317 VPWR VGND sg13g2_decap_8
XFILLER_44_35 VPWR VGND sg13g2_decap_4
XFILLER_12_258 VPWR VGND sg13g2_decap_8
XFILLER_40_512 VPWR VGND sg13g2_decap_8
XFILLER_40_589 VPWR VGND sg13g2_decap_8
XFILLER_44_79 VPWR VGND sg13g2_decap_8
Xclkbuf_5_16__f_clk clknet_5_16__leaf_clk clknet_4_8_0_clk VPWR VGND sg13g2_buf_16
XFILLER_5_18 VPWR VGND sg13g2_decap_8
XFILLER_4_424 VPWR VGND sg13g2_decap_8
XFILLER_36_807 VPWR VGND sg13g2_fill_1
XFILLER_36_818 VPWR VGND sg13g2_decap_4
XFILLER_47_133 VPWR VGND sg13g2_decap_8
XFILLER_48_623 VPWR VGND sg13g2_decap_8
XFILLER_18_91 VPWR VGND sg13g2_decap_8
XFILLER_31_534 VPWR VGND sg13g2_decap_8
XFILLER_43_383 VPWR VGND sg13g2_decap_8
XFILLER_11_291 VPWR VGND sg13g2_decap_8
X_0613_ VGND VPWR net27 daisychain\[36\] _0371_ net47 sg13g2_a21oi_1
XFILLER_7_273 VPWR VGND sg13g2_decap_8
X_0544_ _0213_ net64 _0318_ _0319_ VPWR VGND sg13g2_a21o_1
X_0475_ net78 VPWR _0267_ VGND net75 state\[3\] sg13g2_o21ai_1
XFILLER_15_0 VPWR VGND sg13g2_fill_2
XFILLER_34_350 VPWR VGND sg13g2_decap_8
XFILLER_38_133 VPWR VGND sg13g2_decap_8
XFILLER_39_667 VPWR VGND sg13g2_fill_2
X_1027_ net98 VGND VPWR _0187_ state\[59\] clknet_5_26__leaf_clk sg13g2_dfrbpq_1
XFILLER_22_567 VPWR VGND sg13g2_decap_8
XFILLER_1_427 VPWR VGND sg13g2_decap_8
XFILLER_29_111 VPWR VGND sg13g2_decap_8
XFILLER_29_188 VPWR VGND sg13g2_decap_8
XFILLER_39_68 VPWR VGND sg13g2_decap_8
XFILLER_13_534 VPWR VGND sg13g2_decap_8
XFILLER_25_394 VPWR VGND sg13g2_decap_8
XFILLER_44_114 VPWR VGND sg13g2_decap_8
XFILLER_40_386 VPWR VGND sg13g2_decap_8
XFILLER_4_221 VPWR VGND sg13g2_decap_8
XFILLER_4_298 VPWR VGND sg13g2_decap_8
XFILLER_48_420 VPWR VGND sg13g2_decap_8
XFILLER_23_309 VPWR VGND sg13g2_decap_8
XFILLER_29_90 VPWR VGND sg13g2_decap_8
XFILLER_35_147 VPWR VGND sg13g2_decap_8
XFILLER_48_497 VPWR VGND sg13g2_decap_8
XFILLER_16_361 VPWR VGND sg13g2_decap_8
XFILLER_31_331 VPWR VGND sg13g2_decap_8
XFILLER_6_50 VPWR VGND sg13g2_decap_8
XFILLER_27_615 VPWR VGND sg13g2_decap_8
X_0527_ net84 VPWR _0306_ VGND net63 state\[16\] sg13g2_o21ai_1
X_0458_ VPWR _0023_ state\[62\] VGND sg13g2_inv_1
XFILLER_25_37 VPWR VGND sg13g2_decap_8
XFILLER_26_147 VPWR VGND sg13g2_decap_8
XFILLER_10_559 VPWR VGND sg13g2_decap_8
XFILLER_22_364 VPWR VGND sg13g2_decap_8
XFILLER_1_224 VPWR VGND sg13g2_decap_8
XFILLER_2_703 VPWR VGND sg13g2_decap_4
XFILLER_49_228 VPWR VGND sg13g2_decap_8
XFILLER_17_169 VPWR VGND sg13g2_decap_8
XFILLER_18_637 VPWR VGND sg13g2_decap_8
XFILLER_45_434 VPWR VGND sg13g2_decap_8
XFILLER_13_331 VPWR VGND sg13g2_decap_8
XFILLER_14_810 VPWR VGND sg13g2_decap_8
XFILLER_14_821 VPWR VGND sg13g2_fill_2
XFILLER_25_191 VPWR VGND sg13g2_decap_8
XFILLER_40_183 VPWR VGND sg13g2_decap_8
XFILLER_9_368 VPWR VGND sg13g2_decap_8
XFILLER_23_106 VPWR VGND sg13g2_decap_8
XFILLER_36_434 VPWR VGND sg13g2_decap_8
XFILLER_48_294 VPWR VGND sg13g2_decap_8
XFILLER_11_39 VPWR VGND sg13g2_decap_8
XFILLER_32_662 VPWR VGND sg13g2_decap_8
XFILLER_15_607 VPWR VGND sg13g2_decap_8
XFILLER_27_412 VPWR VGND sg13g2_decap_8
XFILLER_36_14 VPWR VGND sg13g2_decap_8
XFILLER_39_250 VPWR VGND sg13g2_decap_8
XFILLER_14_128 VPWR VGND sg13g2_decap_8
XFILLER_22_161 VPWR VGND sg13g2_decap_8
XFILLER_23_673 VPWR VGND sg13g2_decap_8
XFILLER_27_489 VPWR VGND sg13g2_decap_8
XFILLER_42_448 VPWR VGND sg13g2_decap_8
XFILLER_10_356 VPWR VGND sg13g2_decap_8
XFILLER_2_522 VPWR VGND sg13g2_decap_8
XFILLER_6_316 VPWR VGND sg13g2_decap_8
XFILLER_18_434 VPWR VGND sg13g2_decap_8
XFILLER_26_91 VPWR VGND sg13g2_decap_8
XFILLER_33_459 VPWR VGND sg13g2_decap_8
XFILLER_45_231 VPWR VGND sg13g2_decap_8
XFILLER_14_684 VPWR VGND sg13g2_decap_8
X_0861_ VPWR _0230_ daisychain\[37\] VGND sg13g2_inv_1
X_0930_ net100 VGND VPWR _0090_ daisychain\[26\] clknet_5_11__leaf_clk sg13g2_dfrbpq_1
X_0792_ VPWR _0057_ state\[3\] VGND sg13g2_inv_1
XFILLER_9_165 VPWR VGND sg13g2_decap_8
XFILLER_5_382 VPWR VGND sg13g2_decap_8
XFILLER_36_231 VPWR VGND sg13g2_decap_8
XFILLER_37_732 VPWR VGND sg13g2_fill_1
XFILLER_3_95 VPWR VGND sg13g2_decap_8
XFILLER_49_592 VPWR VGND sg13g2_decap_8
XFILLER_11_109 VPWR VGND sg13g2_decap_8
XFILLER_24_448 VPWR VGND sg13g2_decap_8
XFILLER_20_654 VPWR VGND sg13g2_decap_8
XFILLER_22_49 VPWR VGND sg13g2_decap_8
XFILLER_3_319 VPWR VGND sg13g2_decap_8
XFILLER_47_35 VPWR VGND sg13g2_decap_8
XFILLER_47_518 VPWR VGND sg13g2_decap_8
Xfanout100 net102 net100 VPWR VGND sg13g2_buf_1
Xfanout111 net116 net111 VPWR VGND sg13g2_buf_1
XFILLER_15_415 VPWR VGND sg13g2_decap_8
XFILLER_27_286 VPWR VGND sg13g2_decap_8
XFILLER_28_732 VPWR VGND sg13g2_decap_8
XFILLER_28_743 VPWR VGND sg13g2_fill_1
XFILLER_28_754 VPWR VGND sg13g2_decap_4
XFILLER_28_776 VPWR VGND sg13g2_decap_8
XFILLER_28_787 VPWR VGND sg13g2_fill_1
XFILLER_42_245 VPWR VGND sg13g2_decap_8
XFILLER_10_153 VPWR VGND sg13g2_decap_8
XFILLER_23_470 VPWR VGND sg13g2_decap_8
XFILLER_7_614 VPWR VGND sg13g2_fill_2
XFILLER_6_113 VPWR VGND sg13g2_decap_8
XFILLER_18_231 VPWR VGND sg13g2_decap_8
XFILLER_2_396 VPWR VGND sg13g2_decap_8
XFILLER_38_518 VPWR VGND sg13g2_decap_8
XFILLER_14_492 VPWR VGND sg13g2_decap_8
XFILLER_21_407 VPWR VGND sg13g2_decap_8
XFILLER_33_256 VPWR VGND sg13g2_decap_8
XFILLER_34_757 VPWR VGND sg13g2_fill_2
XFILLER_46_595 VPWR VGND sg13g2_decap_8
X_0913_ net101 VGND VPWR _0073_ daisychain\[9\] clknet_5_5__leaf_clk sg13g2_dfrbpq_1
X_0844_ VPWR _0053_ state\[29\] VGND sg13g2_inv_1
X_0775_ _0424_ VPWR _0183_ VGND net89 _0015_ sg13g2_o21ai_1
XFILLER_45_0 VPWR VGND sg13g2_decap_8
XFILLER_24_245 VPWR VGND sg13g2_decap_8
XFILLER_37_595 VPWR VGND sg13g2_decap_8
XFILLER_20_451 VPWR VGND sg13g2_decap_8
XFILLER_0_812 VPWR VGND sg13g2_decap_8
XFILLER_3_116 VPWR VGND sg13g2_decap_8
XFILLER_47_315 VPWR VGND sg13g2_decap_8
XFILLER_15_212 VPWR VGND sg13g2_decap_8
XFILLER_15_289 VPWR VGND sg13g2_decap_8
XFILLER_43_532 VPWR VGND sg13g2_decap_8
XFILLER_11_473 VPWR VGND sg13g2_decap_8
XFILLER_23_92 VPWR VGND sg13g2_decap_8
XFILLER_7_455 VPWR VGND sg13g2_decap_8
XFILLER_2_193 VPWR VGND sg13g2_decap_8
X_0560_ _0217_ net62 _0330_ _0331_ VPWR VGND sg13g2_a21o_1
X_0491_ net79 VPWR _0279_ VGND net57 state\[7\] sg13g2_o21ai_1
XFILLER_0_63 VPWR VGND sg13g2_decap_8
XFILLER_17_4 VPWR VGND sg13g2_fill_1
XFILLER_34_532 VPWR VGND sg13g2_decap_8
XFILLER_38_315 VPWR VGND sg13g2_decap_8
XFILLER_46_392 VPWR VGND sg13g2_decap_8
X_1043_ state\[59\] net10 VPWR VGND sg13g2_buf_1
XFILLER_21_204 VPWR VGND sg13g2_decap_8
X_0827_ VPWR _0213_ daisychain\[20\] VGND sg13g2_inv_1
X_0758_ _0373_ VPWR _0166_ VGND net93 _0028_ sg13g2_o21ai_1
XFILLER_0_119 VPWR VGND sg13g2_decap_8
X_0689_ VGND VPWR net30 daisychain\[55\] _0428_ net48 sg13g2_a21oi_1
XFILLER_25_565 VPWR VGND sg13g2_decap_8
XFILLER_37_392 VPWR VGND sg13g2_decap_8
XFILLER_44_14 VPWR VGND sg13g2_decap_8
XFILLER_12_237 VPWR VGND sg13g2_decap_8
XFILLER_40_568 VPWR VGND sg13g2_decap_8
XFILLER_4_403 VPWR VGND sg13g2_decap_8
XFILLER_0_642 VPWR VGND sg13g2_fill_1
XFILLER_48_602 VPWR VGND sg13g2_decap_8
XFILLER_0_686 VPWR VGND sg13g2_decap_4
XFILLER_18_70 VPWR VGND sg13g2_decap_8
XFILLER_35_329 VPWR VGND sg13g2_decap_8
XFILLER_47_112 VPWR VGND sg13g2_decap_8
XFILLER_47_189 VPWR VGND sg13g2_decap_8
XFILLER_31_513 VPWR VGND sg13g2_decap_8
XFILLER_34_91 VPWR VGND sg13g2_decap_8
XFILLER_43_362 VPWR VGND sg13g2_decap_8
XFILLER_11_270 VPWR VGND sg13g2_decap_8
X_0612_ _0230_ net67 _0369_ _0370_ VPWR VGND sg13g2_a21o_1
XFILLER_7_252 VPWR VGND sg13g2_decap_8
XFILLER_38_112 VPWR VGND sg13g2_decap_8
XFILLER_3_480 VPWR VGND sg13g2_decap_8
X_0543_ net84 VPWR _0318_ VGND net64 state\[20\] sg13g2_o21ai_1
X_0474_ _0066_ _0265_ _0266_ net36 _0195_ VPWR VGND sg13g2_a22oi_1
XFILLER_26_329 VPWR VGND sg13g2_decap_8
XFILLER_38_189 VPWR VGND sg13g2_decap_8
X_1026_ net98 VGND VPWR _0186_ state\[58\] clknet_5_27__leaf_clk sg13g2_dfrbpq_1
Xclkbuf_5_22__f_clk clknet_5_22__leaf_clk clknet_4_11_0_clk VPWR VGND sg13g2_buf_16
XFILLER_22_546 VPWR VGND sg13g2_decap_8
XFILLER_1_406 VPWR VGND sg13g2_decap_8
XFILLER_39_47 VPWR VGND sg13g2_decap_8
XFILLER_29_167 VPWR VGND sg13g2_decap_8
XFILLER_13_513 VPWR VGND sg13g2_decap_8
XFILLER_25_373 VPWR VGND sg13g2_decap_8
XFILLER_40_365 VPWR VGND sg13g2_decap_8
XFILLER_4_200 VPWR VGND sg13g2_decap_8
XFILLER_0_483 VPWR VGND sg13g2_decap_8
XFILLER_4_277 VPWR VGND sg13g2_decap_8
XFILLER_16_340 VPWR VGND sg13g2_decap_8
XFILLER_31_310 VPWR VGND sg13g2_decap_8
XFILLER_35_126 VPWR VGND sg13g2_decap_8
XFILLER_36_616 VPWR VGND sg13g2_decap_8
XFILLER_48_476 VPWR VGND sg13g2_decap_8
XFILLER_31_387 VPWR VGND sg13g2_decap_8
X_0526_ _0079_ _0304_ _0305_ net45 _0208_ VPWR VGND sg13g2_a22oi_1
XFILLER_26_126 VPWR VGND sg13g2_decap_8
X_0457_ VPWR _0254_ daisychain\[61\] VGND sg13g2_inv_1
XFILLER_22_343 VPWR VGND sg13g2_decap_8
XFILLER_23_822 VPWR VGND sg13g2_fill_1
X_1009_ net113 VGND VPWR _0169_ state\[41\] clknet_5_19__leaf_clk sg13g2_dfrbpq_1
XFILLER_10_538 VPWR VGND sg13g2_decap_8
XFILLER_1_203 VPWR VGND sg13g2_decap_8
XFILLER_49_207 VPWR VGND sg13g2_decap_8
XFILLER_17_148 VPWR VGND sg13g2_decap_8
XFILLER_18_616 VPWR VGND sg13g2_decap_8
XFILLER_26_693 VPWR VGND sg13g2_decap_8
XFILLER_45_413 VPWR VGND sg13g2_decap_8
XFILLER_13_310 VPWR VGND sg13g2_decap_8
XFILLER_13_387 VPWR VGND sg13g2_decap_8
XFILLER_15_93 VPWR VGND sg13g2_decap_8
XFILLER_25_170 VPWR VGND sg13g2_decap_8
XFILLER_40_162 VPWR VGND sg13g2_decap_8
XFILLER_41_685 VPWR VGND sg13g2_fill_1
XFILLER_9_347 VPWR VGND sg13g2_decap_8
XFILLER_0_280 VPWR VGND sg13g2_decap_8
XFILLER_36_413 VPWR VGND sg13g2_decap_8
XFILLER_49_741 VPWR VGND sg13g2_decap_8
XFILLER_48_273 VPWR VGND sg13g2_decap_8
XFILLER_32_641 VPWR VGND sg13g2_decap_8
XFILLER_11_18 VPWR VGND sg13g2_decap_8
XFILLER_31_184 VPWR VGND sg13g2_decap_8
XFILLER_8_391 VPWR VGND sg13g2_decap_8
X_0509_ VGND VPWR net23 daisychain\[10\] _0293_ net37 sg13g2_a21oi_1
XFILLER_14_107 VPWR VGND sg13g2_decap_8
XFILLER_27_468 VPWR VGND sg13g2_decap_8
XFILLER_42_427 VPWR VGND sg13g2_decap_8
XFILLER_10_335 VPWR VGND sg13g2_decap_8
XFILLER_22_140 VPWR VGND sg13g2_decap_8
XFILLER_23_652 VPWR VGND sg13g2_decap_8
XFILLER_35_490 VPWR VGND sg13g2_decap_8
XFILLER_2_501 VPWR VGND sg13g2_decap_8
XFILLER_18_413 VPWR VGND sg13g2_decap_8
XFILLER_45_210 VPWR VGND sg13g2_decap_8
XFILLER_26_490 VPWR VGND sg13g2_decap_8
XFILLER_26_70 VPWR VGND sg13g2_decap_8
XFILLER_33_438 VPWR VGND sg13g2_decap_8
XFILLER_45_287 VPWR VGND sg13g2_decap_8
XFILLER_13_184 VPWR VGND sg13g2_decap_8
XFILLER_41_482 VPWR VGND sg13g2_decap_8
X_0860_ VPWR _0027_ state\[37\] VGND sg13g2_inv_1
X_0791_ VPWR _0195_ daisychain\[2\] VGND sg13g2_inv_1
XFILLER_9_144 VPWR VGND sg13g2_decap_8
XFILLER_3_74 VPWR VGND sg13g2_decap_8
XFILLER_5_361 VPWR VGND sg13g2_decap_8
XFILLER_24_427 VPWR VGND sg13g2_decap_8
XFILLER_36_210 VPWR VGND sg13g2_decap_8
XFILLER_36_287 VPWR VGND sg13g2_decap_8
XFILLER_49_571 VPWR VGND sg13g2_decap_8
XFILLER_20_633 VPWR VGND sg13g2_decap_8
X_0989_ net108 VGND VPWR _0149_ state\[21\] clknet_5_14__leaf_clk sg13g2_dfrbpq_1
XFILLER_28_711 VPWR VGND sg13g2_decap_8
XFILLER_47_14 VPWR VGND sg13g2_decap_8
Xfanout101 net102 net101 VPWR VGND sg13g2_buf_1
Xfanout112 net113 net112 VPWR VGND sg13g2_buf_1
XFILLER_27_265 VPWR VGND sg13g2_decap_8
XFILLER_42_224 VPWR VGND sg13g2_decap_8
XFILLER_10_132 VPWR VGND sg13g2_decap_8
XFILLER_12_83 VPWR VGND sg13g2_decap_8
XFILLER_2_375 VPWR VGND sg13g2_decap_8
XFILLER_3_821 VPWR VGND sg13g2_fill_2
XFILLER_6_169 VPWR VGND sg13g2_decap_8
XFILLER_18_210 VPWR VGND sg13g2_decap_8
XFILLER_19_711 VPWR VGND sg13g2_fill_2
XFILLER_19_8 VPWR VGND sg13g2_fill_1
XFILLER_37_91 VPWR VGND sg13g2_decap_8
XFILLER_46_574 VPWR VGND sg13g2_decap_8
Xclkbuf_5_3__f_clk clknet_5_3__leaf_clk clknet_4_1_0_clk VPWR VGND sg13g2_buf_16
XFILLER_14_471 VPWR VGND sg13g2_decap_8
XFILLER_18_287 VPWR VGND sg13g2_decap_8
XFILLER_33_235 VPWR VGND sg13g2_decap_8
X_0912_ net101 VGND VPWR _0072_ daisychain\[8\] clknet_5_6__leaf_clk sg13g2_dfrbpq_1
X_0843_ VPWR _0221_ daisychain\[28\] VGND sg13g2_inv_1
X_0774_ _0421_ VPWR _0182_ VGND net90 _0014_ sg13g2_o21ai_1
XFILLER_38_0 VPWR VGND sg13g2_decap_8
XFILLER_12_419 VPWR VGND sg13g2_decap_8
XFILLER_17_17 VPWR VGND sg13g2_fill_1
XFILLER_24_224 VPWR VGND sg13g2_decap_8
XFILLER_25_769 VPWR VGND sg13g2_fill_2
XFILLER_37_574 VPWR VGND sg13g2_decap_8
XFILLER_20_430 VPWR VGND sg13g2_decap_8
XFILLER_28_585 VPWR VGND sg13g2_decap_8
XFILLER_43_511 VPWR VGND sg13g2_decap_8
XFILLER_15_268 VPWR VGND sg13g2_decap_8
XFILLER_30_249 VPWR VGND sg13g2_decap_8
XFILLER_31_739 VPWR VGND sg13g2_decap_4
XFILLER_43_588 VPWR VGND sg13g2_decap_8
XFILLER_11_452 VPWR VGND sg13g2_decap_8
XFILLER_23_71 VPWR VGND sg13g2_decap_8
XFILLER_7_434 VPWR VGND sg13g2_decap_8
XFILLER_2_172 VPWR VGND sg13g2_decap_8
X_0490_ _0070_ _0277_ _0278_ net37 _0199_ VPWR VGND sg13g2_a22oi_1
XFILLER_0_42 VPWR VGND sg13g2_decap_8
XFILLER_19_585 VPWR VGND sg13g2_decap_8
XFILLER_34_511 VPWR VGND sg13g2_decap_8
XFILLER_46_371 VPWR VGND sg13g2_decap_8
X_1042_ state\[58\] net9 VPWR VGND sg13g2_buf_1
XFILLER_15_791 VPWR VGND sg13g2_fill_2
XFILLER_30_794 VPWR VGND sg13g2_fill_1
XFILLER_34_588 VPWR VGND sg13g2_decap_8
XFILLER_9_95 VPWR VGND sg13g2_decap_8
X_0826_ VPWR _0044_ state\[20\] VGND sg13g2_inv_1
X_0757_ _0370_ VPWR _0165_ VGND net88 _0027_ sg13g2_o21ai_1
X_0688_ _0249_ net68 _0426_ _0427_ VPWR VGND sg13g2_a21o_1
XFILLER_29_349 VPWR VGND sg13g2_decap_8
Xclkbuf_4_15_0_clk clknet_0_clk clknet_4_15_0_clk VPWR VGND sg13g2_buf_8
XFILLER_12_216 VPWR VGND sg13g2_decap_8
XFILLER_25_544 VPWR VGND sg13g2_decap_8
XFILLER_37_371 VPWR VGND sg13g2_decap_8
XFILLER_40_547 VPWR VGND sg13g2_decap_8
XFILLER_8_209 VPWR VGND sg13g2_decap_8
XFILLER_0_610 VPWR VGND sg13g2_fill_2
XFILLER_0_654 VPWR VGND sg13g2_fill_1
XFILLER_0_665 VPWR VGND sg13g2_decap_8
XFILLER_4_459 VPWR VGND sg13g2_decap_8
XFILLER_16_544 VPWR VGND sg13g2_fill_2
XFILLER_28_382 VPWR VGND sg13g2_decap_8
XFILLER_35_308 VPWR VGND sg13g2_decap_8
XFILLER_43_341 VPWR VGND sg13g2_decap_8
XFILLER_47_168 VPWR VGND sg13g2_decap_8
XFILLER_16_599 VPWR VGND sg13g2_decap_8
XFILLER_31_569 VPWR VGND sg13g2_decap_8
XFILLER_34_70 VPWR VGND sg13g2_decap_8
XFILLER_7_231 VPWR VGND sg13g2_decap_8
X_0611_ net88 VPWR _0369_ VGND net67 state\[37\] sg13g2_o21ai_1
X_0542_ _0083_ _0316_ _0317_ net42 _0212_ VPWR VGND sg13g2_a22oi_1
XFILLER_26_308 VPWR VGND sg13g2_decap_8
XFILLER_38_168 VPWR VGND sg13g2_decap_8
X_0473_ VGND VPWR net32 daisychain\[1\] _0266_ net36 sg13g2_a21oi_1
XFILLER_19_382 VPWR VGND sg13g2_decap_8
XFILLER_22_525 VPWR VGND sg13g2_decap_8
XFILLER_34_385 VPWR VGND sg13g2_decap_8
XFILLER_47_680 VPWR VGND sg13g2_decap_4
X_1025_ net117 VGND VPWR _0185_ state\[57\] clknet_5_24__leaf_clk sg13g2_dfrbpq_1
XFILLER_30_39 VPWR VGND sg13g2_decap_8
X_0809_ VPWR _0204_ daisychain\[11\] VGND sg13g2_inv_1
XFILLER_25_352 VPWR VGND sg13g2_decap_8
XFILLER_29_146 VPWR VGND sg13g2_decap_8
XFILLER_44_149 VPWR VGND sg13g2_decap_8
XFILLER_13_569 VPWR VGND sg13g2_decap_8
XFILLER_40_344 VPWR VGND sg13g2_decap_8
XFILLER_9_529 VPWR VGND sg13g2_decap_8
XFILLER_20_94 VPWR VGND sg13g2_decap_8
XFILLER_4_256 VPWR VGND sg13g2_decap_8
XFILLER_0_462 VPWR VGND sg13g2_decap_8
XFILLER_48_455 VPWR VGND sg13g2_decap_8
XFILLER_16_396 VPWR VGND sg13g2_decap_8
XFILLER_35_105 VPWR VGND sg13g2_decap_8
XFILLER_36_639 VPWR VGND sg13g2_decap_8
XFILLER_44_694 VPWR VGND sg13g2_fill_1
XFILLER_45_91 VPWR VGND sg13g2_decap_8
XANTENNA_1 VPWR VGND digitalen.g\[1\].u.OUTP sg13g2_antennanp
XFILLER_12_580 VPWR VGND sg13g2_decap_8
XFILLER_31_366 VPWR VGND sg13g2_decap_8
XFILLER_8_573 VPWR VGND sg13g2_decap_8
X_0525_ VGND VPWR net26 daisychain\[14\] _0305_ net45 sg13g2_a21oi_1
X_0456_ VPWR _0021_ state\[61\] VGND sg13g2_inv_1
XFILLER_6_85 VPWR VGND sg13g2_decap_8
XFILLER_26_105 VPWR VGND sg13g2_decap_8
XFILLER_39_433 VPWR VGND sg13g2_fill_2
XFILLER_10_517 VPWR VGND sg13g2_decap_8
XFILLER_22_322 VPWR VGND sg13g2_decap_8
XFILLER_22_399 VPWR VGND sg13g2_decap_8
XFILLER_34_182 VPWR VGND sg13g2_decap_8
XFILLER_35_683 VPWR VGND sg13g2_decap_8
XFILLER_35_694 VPWR VGND sg13g2_fill_1
XFILLER_41_119 VPWR VGND sg13g2_decap_8
X_1008_ net113 VGND VPWR _0168_ state\[40\] clknet_5_21__leaf_clk sg13g2_dfrbpq_1
XFILLER_41_49 VPWR VGND sg13g2_decap_8
XFILLER_1_259 VPWR VGND sg13g2_decap_8
XFILLER_17_127 VPWR VGND sg13g2_decap_8
XFILLER_26_672 VPWR VGND sg13g2_decap_8
XFILLER_41_631 VPWR VGND sg13g2_decap_8
XFILLER_45_469 VPWR VGND sg13g2_decap_8
XFILLER_13_366 VPWR VGND sg13g2_decap_8
XFILLER_15_72 VPWR VGND sg13g2_decap_8
XFILLER_40_141 VPWR VGND sg13g2_decap_8
XFILLER_9_326 VPWR VGND sg13g2_decap_8
XFILLER_31_93 VPWR VGND sg13g2_decap_8
XFILLER_5_543 VPWR VGND sg13g2_decap_4
XFILLER_24_609 VPWR VGND sg13g2_decap_8
XFILLER_36_469 VPWR VGND sg13g2_decap_8
XFILLER_48_252 VPWR VGND sg13g2_decap_8
XFILLER_16_193 VPWR VGND sg13g2_decap_8
XFILLER_17_661 VPWR VGND sg13g2_fill_1
XFILLER_17_694 VPWR VGND sg13g2_fill_1
XFILLER_31_163 VPWR VGND sg13g2_decap_8
XFILLER_32_620 VPWR VGND sg13g2_decap_8
XFILLER_8_370 VPWR VGND sg13g2_decap_8
X_0508_ _0204_ net59 _0291_ _0292_ VPWR VGND sg13g2_a21o_1
XFILLER_23_631 VPWR VGND sg13g2_decap_8
XFILLER_27_447 VPWR VGND sg13g2_decap_8
XFILLER_36_49 VPWR VGND sg13g2_decap_8
XFILLER_39_285 VPWR VGND sg13g2_decap_8
XFILLER_42_406 VPWR VGND sg13g2_decap_8
XFILLER_10_314 VPWR VGND sg13g2_decap_8
XFILLER_22_196 VPWR VGND sg13g2_decap_8
XFILLER_2_557 VPWR VGND sg13g2_decap_8
XFILLER_2_568 VPWR VGND sg13g2_fill_2
XFILLER_18_469 VPWR VGND sg13g2_decap_8
XFILLER_13_163 VPWR VGND sg13g2_decap_8
XFILLER_14_653 VPWR VGND sg13g2_fill_1
XFILLER_14_675 VPWR VGND sg13g2_decap_4
XFILLER_33_417 VPWR VGND sg13g2_decap_8
XFILLER_41_461 VPWR VGND sg13g2_decap_8
XFILLER_45_266 VPWR VGND sg13g2_decap_8
XFILLER_9_123 VPWR VGND sg13g2_decap_8
X_0790_ VPWR _0054_ state\[2\] VGND sg13g2_inv_1
XFILLER_5_340 VPWR VGND sg13g2_decap_8
XFILLER_3_53 VPWR VGND sg13g2_decap_8
XFILLER_49_550 VPWR VGND sg13g2_decap_8
XFILLER_17_491 VPWR VGND sg13g2_decap_8
XFILLER_24_406 VPWR VGND sg13g2_decap_8
XFILLER_36_266 VPWR VGND sg13g2_decap_8
XFILLER_20_612 VPWR VGND sg13g2_decap_8
XFILLER_20_689 VPWR VGND sg13g2_decap_8
XFILLER_32_494 VPWR VGND sg13g2_decap_8
X_0988_ net108 VGND VPWR _0148_ state\[20\] clknet_5_16__leaf_clk sg13g2_dfrbpq_1
Xfanout102 net103 net102 VPWR VGND sg13g2_buf_1
Xfanout113 net115 net113 VPWR VGND sg13g2_buf_1
XFILLER_27_244 VPWR VGND sg13g2_decap_8
XFILLER_42_203 VPWR VGND sg13g2_decap_8
XFILLER_10_111 VPWR VGND sg13g2_decap_8
XFILLER_10_188 VPWR VGND sg13g2_decap_8
XFILLER_12_62 VPWR VGND sg13g2_decap_8
XFILLER_7_627 VPWR VGND sg13g2_decap_8
XFILLER_7_616 VPWR VGND sg13g2_fill_1
XFILLER_6_148 VPWR VGND sg13g2_decap_8
XFILLER_2_354 VPWR VGND sg13g2_decap_8
XFILLER_18_266 VPWR VGND sg13g2_decap_8
XFILLER_19_767 VPWR VGND sg13g2_fill_2
XFILLER_33_214 VPWR VGND sg13g2_decap_8
XFILLER_37_70 VPWR VGND sg13g2_decap_8
XFILLER_46_553 VPWR VGND sg13g2_decap_8
XFILLER_14_450 VPWR VGND sg13g2_decap_8
X_0911_ net100 VGND VPWR _0071_ daisychain\[7\] clknet_5_8__leaf_clk sg13g2_dfrbpq_1
X_0842_ VPWR _0052_ state\[28\] VGND sg13g2_inv_1
X_0773_ _0418_ VPWR _0181_ VGND net94 _0013_ sg13g2_o21ai_1
XFILLER_17_29 VPWR VGND sg13g2_decap_8
XFILLER_24_203 VPWR VGND sg13g2_decap_8
XFILLER_25_737 VPWR VGND sg13g2_decap_8
XFILLER_33_39 VPWR VGND sg13g2_decap_8
XFILLER_33_792 VPWR VGND sg13g2_fill_1
XFILLER_37_553 VPWR VGND sg13g2_decap_8
XFILLER_20_486 VPWR VGND sg13g2_decap_8
XFILLER_32_291 VPWR VGND sg13g2_decap_8
XFILLER_28_564 VPWR VGND sg13g2_decap_8
XFILLER_11_431 VPWR VGND sg13g2_decap_8
XFILLER_15_247 VPWR VGND sg13g2_decap_8
XFILLER_23_50 VPWR VGND sg13g2_decap_8
XFILLER_24_781 VPWR VGND sg13g2_decap_4
XFILLER_30_228 VPWR VGND sg13g2_decap_8
XFILLER_43_567 VPWR VGND sg13g2_decap_8
XFILLER_7_413 VPWR VGND sg13g2_decap_8
XFILLER_2_151 VPWR VGND sg13g2_decap_8
XFILLER_48_91 VPWR VGND sg13g2_decap_8
XFILLER_0_21 VPWR VGND sg13g2_decap_8
XFILLER_0_98 VPWR VGND sg13g2_decap_8
XFILLER_19_564 VPWR VGND sg13g2_decap_8
XFILLER_22_729 VPWR VGND sg13g2_decap_4
XFILLER_34_567 VPWR VGND sg13g2_decap_8
XFILLER_46_350 VPWR VGND sg13g2_decap_8
X_1041_ state\[57\] net8 VPWR VGND sg13g2_buf_1
XFILLER_21_239 VPWR VGND sg13g2_decap_8
X_0825_ VPWR _0212_ daisychain\[19\] VGND sg13g2_inv_1
XFILLER_9_74 VPWR VGND sg13g2_decap_8
X_0756_ _0367_ VPWR _0164_ VGND net89 _0026_ sg13g2_o21ai_1
X_0687_ net89 VPWR _0426_ VGND net68 state\[56\] sg13g2_o21ai_1
XFILLER_25_523 VPWR VGND sg13g2_decap_8
XFILLER_28_39 VPWR VGND sg13g2_decap_8
XFILLER_29_328 VPWR VGND sg13g2_decap_8
XFILLER_37_350 VPWR VGND sg13g2_decap_8
XFILLER_40_526 VPWR VGND sg13g2_decap_8
XFILLER_20_283 VPWR VGND sg13g2_decap_8
XFILLER_4_438 VPWR VGND sg13g2_decap_8
XFILLER_0_699 VPWR VGND sg13g2_fill_1
XFILLER_48_637 VPWR VGND sg13g2_decap_8
XFILLER_16_523 VPWR VGND sg13g2_decap_8
XFILLER_16_567 VPWR VGND sg13g2_decap_8
XFILLER_28_361 VPWR VGND sg13g2_decap_8
XFILLER_43_320 VPWR VGND sg13g2_decap_8
XFILLER_47_147 VPWR VGND sg13g2_decap_8
XFILLER_31_548 VPWR VGND sg13g2_decap_8
XFILLER_43_397 VPWR VGND sg13g2_decap_8
XFILLER_7_210 VPWR VGND sg13g2_decap_8
X_0610_ _0100_ _0367_ _0368_ net48 _0229_ VPWR VGND sg13g2_a22oi_1
X_0541_ VGND VPWR net25 daisychain\[18\] _0317_ net42 sg13g2_a21oi_1
X_0472_ _0195_ net75 _0264_ _0265_ VPWR VGND sg13g2_a21o_1
XFILLER_7_287 VPWR VGND sg13g2_decap_8
XFILLER_19_361 VPWR VGND sg13g2_decap_8
XFILLER_22_4 VPWR VGND sg13g2_decap_8
XFILLER_35_821 VPWR VGND sg13g2_fill_2
XFILLER_38_147 VPWR VGND sg13g2_decap_8
XFILLER_39_604 VPWR VGND sg13g2_decap_8
X_1024_ net110 VGND VPWR _0184_ state\[56\] clknet_5_24__leaf_clk sg13g2_dfrbpq_1
XFILLER_22_504 VPWR VGND sg13g2_decap_8
XFILLER_34_364 VPWR VGND sg13g2_decap_8
XFILLER_30_18 VPWR VGND sg13g2_decap_8
XFILLER_30_592 VPWR VGND sg13g2_decap_8
X_0808_ VPWR _0034_ state\[11\] VGND sg13g2_inv_1
XFILLER_29_125 VPWR VGND sg13g2_decap_8
X_0739_ _0316_ VPWR _0147_ VGND net85 _0042_ sg13g2_o21ai_1
XFILLER_17_309 VPWR VGND sg13g2_decap_8
XFILLER_25_331 VPWR VGND sg13g2_decap_8
XFILLER_38_670 VPWR VGND sg13g2_decap_4
XFILLER_38_681 VPWR VGND sg13g2_fill_1
XFILLER_44_128 VPWR VGND sg13g2_decap_8
XFILLER_45_607 VPWR VGND sg13g2_fill_2
XFILLER_13_548 VPWR VGND sg13g2_decap_8
XFILLER_40_323 VPWR VGND sg13g2_decap_8
XFILLER_9_508 VPWR VGND sg13g2_decap_8
XFILLER_20_73 VPWR VGND sg13g2_decap_8
XFILLER_4_235 VPWR VGND sg13g2_decap_8
XFILLER_0_441 VPWR VGND sg13g2_decap_8
XFILLER_29_692 VPWR VGND sg13g2_decap_8
XFILLER_48_434 VPWR VGND sg13g2_decap_8
XFILLER_16_375 VPWR VGND sg13g2_decap_8
XFILLER_31_345 VPWR VGND sg13g2_decap_8
XFILLER_43_172 VPWR VGND sg13g2_decap_8
XFILLER_43_194 VPWR VGND sg13g2_decap_8
XFILLER_45_70 VPWR VGND sg13g2_decap_8
XANTENNA_2 VPWR VGND state\[2\] sg13g2_antennanp
Xclkbuf_4_14_0_clk clknet_0_clk clknet_4_14_0_clk VPWR VGND sg13g2_buf_8
XFILLER_8_552 VPWR VGND sg13g2_decap_8
XFILLER_6_64 VPWR VGND sg13g2_decap_8
XFILLER_39_412 VPWR VGND sg13g2_decap_8
X_0524_ _0208_ net62 _0303_ _0304_ VPWR VGND sg13g2_a21o_1
X_0455_ VPWR _0253_ daisychain\[60\] VGND sg13g2_inv_1
XFILLER_22_301 VPWR VGND sg13g2_decap_8
XFILLER_27_629 VPWR VGND sg13g2_decap_8
XFILLER_34_161 VPWR VGND sg13g2_decap_8
XFILLER_39_456 VPWR VGND sg13g2_decap_8
XFILLER_39_489 VPWR VGND sg13g2_decap_8
X_1007_ net114 VGND VPWR _0167_ state\[39\] clknet_5_28__leaf_clk sg13g2_dfrbpq_1
XFILLER_22_378 VPWR VGND sg13g2_decap_8
XFILLER_41_28 VPWR VGND sg13g2_decap_8
XFILLER_1_238 VPWR VGND sg13g2_decap_8
XFILLER_17_106 VPWR VGND sg13g2_decap_8
XFILLER_13_345 VPWR VGND sg13g2_decap_8
XFILLER_15_51 VPWR VGND sg13g2_decap_8
XFILLER_26_651 VPWR VGND sg13g2_decap_8
XFILLER_32_109 VPWR VGND sg13g2_decap_8
XFILLER_40_120 VPWR VGND sg13g2_decap_8
XFILLER_45_448 VPWR VGND sg13g2_decap_8
XFILLER_9_305 VPWR VGND sg13g2_decap_8
XFILLER_31_72 VPWR VGND sg13g2_decap_8
XFILLER_40_197 VPWR VGND sg13g2_decap_8
XFILLER_5_522 VPWR VGND sg13g2_decap_8
XFILLER_36_448 VPWR VGND sg13g2_decap_8
XFILLER_49_798 VPWR VGND sg13g2_decap_8
XFILLER_49_765 VPWR VGND sg13g2_fill_2
XFILLER_48_231 VPWR VGND sg13g2_decap_8
XFILLER_16_172 VPWR VGND sg13g2_decap_8
XFILLER_31_142 VPWR VGND sg13g2_decap_8
XFILLER_32_676 VPWR VGND sg13g2_decap_8
XFILLER_27_426 VPWR VGND sg13g2_decap_8
XFILLER_36_28 VPWR VGND sg13g2_decap_8
XFILLER_39_264 VPWR VGND sg13g2_decap_8
X_0507_ net80 VPWR _0291_ VGND net59 state\[11\] sg13g2_o21ai_1
XFILLER_23_610 VPWR VGND sg13g2_decap_8
XFILLER_22_175 VPWR VGND sg13g2_decap_8
XFILLER_23_687 VPWR VGND sg13g2_decap_8
XFILLER_2_536 VPWR VGND sg13g2_decap_8
XFILLER_18_448 VPWR VGND sg13g2_decap_8
XFILLER_45_245 VPWR VGND sg13g2_decap_8
XFILLER_13_142 VPWR VGND sg13g2_decap_8
XFILLER_14_698 VPWR VGND sg13g2_decap_8
XFILLER_41_440 VPWR VGND sg13g2_decap_8
XFILLER_9_102 VPWR VGND sg13g2_decap_8
XFILLER_42_93 VPWR VGND sg13g2_decap_8
XFILLER_9_179 VPWR VGND sg13g2_decap_8
XFILLER_5_396 VPWR VGND sg13g2_decap_8
XFILLER_3_32 VPWR VGND sg13g2_decap_8
XFILLER_17_470 VPWR VGND sg13g2_decap_8
XFILLER_36_245 VPWR VGND sg13g2_decap_8
XFILLER_20_668 VPWR VGND sg13g2_decap_8
XFILLER_32_473 VPWR VGND sg13g2_decap_8
X_0987_ net108 VGND VPWR _0147_ state\[19\] clknet_5_15__leaf_clk sg13g2_dfrbpq_1
Xclkbuf_5_28__f_clk clknet_5_28__leaf_clk clknet_4_14_0_clk VPWR VGND sg13g2_buf_16
Xfanout103 net116 net103 VPWR VGND sg13g2_buf_1
Xfanout114 net115 net114 VPWR VGND sg13g2_buf_1
XFILLER_27_223 VPWR VGND sg13g2_decap_8
XFILLER_47_49 VPWR VGND sg13g2_decap_8
XFILLER_15_429 VPWR VGND sg13g2_decap_8
XFILLER_23_484 VPWR VGND sg13g2_decap_8
XFILLER_42_259 VPWR VGND sg13g2_decap_8
XFILLER_7_606 VPWR VGND sg13g2_fill_2
XFILLER_10_167 VPWR VGND sg13g2_decap_8
XFILLER_12_41 VPWR VGND sg13g2_decap_8
XFILLER_6_127 VPWR VGND sg13g2_decap_8
XFILLER_2_333 VPWR VGND sg13g2_decap_8
XFILLER_18_245 VPWR VGND sg13g2_decap_8
XFILLER_19_779 VPWR VGND sg13g2_decap_8
XFILLER_46_532 VPWR VGND sg13g2_decap_8
X_0910_ net100 VGND VPWR _0070_ daisychain\[6\] clknet_5_0__leaf_clk sg13g2_dfrbpq_1
X_0841_ VPWR _0220_ daisychain\[27\] VGND sg13g2_inv_1
X_0772_ _0415_ VPWR _0180_ VGND net90 _0012_ sg13g2_o21ai_1
XFILLER_5_193 VPWR VGND sg13g2_decap_8
XFILLER_25_705 VPWR VGND sg13g2_decap_8
XFILLER_25_716 VPWR VGND sg13g2_decap_8
XFILLER_37_532 VPWR VGND sg13g2_decap_8
XFILLER_24_259 VPWR VGND sg13g2_decap_8
XFILLER_32_270 VPWR VGND sg13g2_decap_8
XFILLER_33_18 VPWR VGND sg13g2_decap_8
XFILLER_33_771 VPWR VGND sg13g2_decap_8
XFILLER_33_782 VPWR VGND sg13g2_fill_1
XFILLER_20_465 VPWR VGND sg13g2_decap_8
XFILLER_47_329 VPWR VGND sg13g2_decap_8
XFILLER_15_226 VPWR VGND sg13g2_decap_8
XFILLER_16_716 VPWR VGND sg13g2_fill_2
XFILLER_28_543 VPWR VGND sg13g2_decap_8
XFILLER_43_546 VPWR VGND sg13g2_decap_8
XFILLER_11_410 VPWR VGND sg13g2_decap_8
XFILLER_11_487 VPWR VGND sg13g2_decap_8
XFILLER_23_281 VPWR VGND sg13g2_decap_8
XFILLER_30_207 VPWR VGND sg13g2_decap_8
XFILLER_2_130 VPWR VGND sg13g2_decap_8
XFILLER_3_620 VPWR VGND sg13g2_fill_1
XFILLER_7_469 VPWR VGND sg13g2_decap_8
XFILLER_19_543 VPWR VGND sg13g2_decap_8
XFILLER_38_329 VPWR VGND sg13g2_decap_8
X_1040_ state\[56\] net7 VPWR VGND sg13g2_buf_1
Xclkbuf_5_11__f_clk clknet_5_11__leaf_clk clknet_4_5_0_clk VPWR VGND sg13g2_buf_16
XFILLER_48_70 VPWR VGND sg13g2_decap_8
XFILLER_0_77 VPWR VGND sg13g2_decap_8
XFILLER_21_218 VPWR VGND sg13g2_decap_8
XFILLER_34_546 VPWR VGND sg13g2_decap_8
XFILLER_9_53 VPWR VGND sg13g2_decap_8
XFILLER_30_785 VPWR VGND sg13g2_decap_4
X_0824_ VPWR _0042_ state\[19\] VGND sg13g2_inv_1
X_0755_ _0364_ VPWR _0163_ VGND net89 _0025_ sg13g2_o21ai_1
XFILLER_28_18 VPWR VGND sg13g2_decap_8
XFILLER_29_307 VPWR VGND sg13g2_decap_8
XFILLER_43_0 VPWR VGND sg13g2_decap_8
X_0686_ _0119_ _0424_ _0425_ net48 _0248_ VPWR VGND sg13g2_a22oi_1
XFILLER_6_491 VPWR VGND sg13g2_decap_8
XFILLER_25_502 VPWR VGND sg13g2_decap_8
XFILLER_44_28 VPWR VGND sg13g2_fill_2
XFILLER_44_39 VPWR VGND sg13g2_fill_1
XFILLER_20_262 VPWR VGND sg13g2_decap_8
XFILLER_25_579 VPWR VGND sg13g2_decap_8
XFILLER_40_505 VPWR VGND sg13g2_decap_8
XFILLER_4_417 VPWR VGND sg13g2_decap_8
XFILLER_0_634 VPWR VGND sg13g2_fill_2
XFILLER_28_340 VPWR VGND sg13g2_decap_8
XFILLER_47_126 VPWR VGND sg13g2_decap_8
XFILLER_48_616 VPWR VGND sg13g2_decap_8
XFILLER_16_546 VPWR VGND sg13g2_fill_1
XFILLER_18_84 VPWR VGND sg13g2_decap_8
XFILLER_31_527 VPWR VGND sg13g2_decap_8
XFILLER_43_376 VPWR VGND sg13g2_decap_8
XFILLER_11_284 VPWR VGND sg13g2_decap_8
XFILLER_7_266 VPWR VGND sg13g2_decap_8
XFILLER_3_494 VPWR VGND sg13g2_decap_8
X_0540_ _0212_ net63 _0315_ _0316_ VPWR VGND sg13g2_a21o_1
X_0471_ net78 VPWR _0264_ VGND net75 state\[2\] sg13g2_o21ai_1
XFILLER_19_340 VPWR VGND sg13g2_decap_8
XFILLER_34_343 VPWR VGND sg13g2_decap_8
XFILLER_38_126 VPWR VGND sg13g2_decap_8
X_1023_ net110 VGND VPWR _0183_ state\[55\] clknet_5_30__leaf_clk sg13g2_dfrbpq_1
XFILLER_30_571 VPWR VGND sg13g2_decap_8
X_0807_ VPWR _0203_ daisychain\[10\] VGND sg13g2_inv_1
X_0738_ _0313_ VPWR _0146_ VGND net84 _0041_ sg13g2_o21ai_1
XFILLER_29_104 VPWR VGND sg13g2_decap_8
X_0669_ VGND VPWR net29 daisychain\[50\] _0413_ net52 sg13g2_a21oi_1
XFILLER_13_527 VPWR VGND sg13g2_decap_8
XFILLER_25_310 VPWR VGND sg13g2_decap_8
XFILLER_25_387 VPWR VGND sg13g2_decap_8
XFILLER_26_822 VPWR VGND sg13g2_fill_1
XFILLER_40_302 VPWR VGND sg13g2_decap_8
XFILLER_44_107 VPWR VGND sg13g2_decap_8
XFILLER_21_582 VPWR VGND sg13g2_decap_8
XFILLER_40_379 VPWR VGND sg13g2_decap_8
XFILLER_4_214 VPWR VGND sg13g2_decap_8
XFILLER_0_420 VPWR VGND sg13g2_decap_8
XFILLER_20_52 VPWR VGND sg13g2_decap_8
XFILLER_0_497 VPWR VGND sg13g2_decap_8
XFILLER_29_671 VPWR VGND sg13g2_decap_8
XFILLER_29_83 VPWR VGND sg13g2_decap_8
XFILLER_48_413 VPWR VGND sg13g2_decap_8
XFILLER_16_354 VPWR VGND sg13g2_decap_8
XFILLER_31_324 VPWR VGND sg13g2_decap_8
XFILLER_43_151 VPWR VGND sg13g2_decap_8
XFILLER_8_531 VPWR VGND sg13g2_decap_8
XANTENNA_3 VPWR VGND digitalen.g\[3\].u.OUTN sg13g2_antennanp
Xclkbuf_5_9__f_clk clknet_5_9__leaf_clk clknet_4_4_0_clk VPWR VGND sg13g2_buf_16
XFILLER_6_43 VPWR VGND sg13g2_decap_8
XFILLER_27_608 VPWR VGND sg13g2_decap_8
XFILLER_39_435 VPWR VGND sg13g2_fill_1
XFILLER_3_291 VPWR VGND sg13g2_decap_8
X_0523_ net83 VPWR _0303_ VGND net62 state\[15\] sg13g2_o21ai_1
X_0454_ VPWR _0020_ state\[60\] VGND sg13g2_inv_1
XFILLER_34_140 VPWR VGND sg13g2_decap_8
XFILLER_35_630 VPWR VGND sg13g2_decap_8
XFILLER_35_674 VPWR VGND sg13g2_fill_2
XFILLER_47_490 VPWR VGND sg13g2_decap_8
X_1006_ net114 VGND VPWR _0166_ state\[38\] clknet_5_31__leaf_clk sg13g2_dfrbpq_1
XFILLER_22_357 VPWR VGND sg13g2_decap_8
XFILLER_1_217 VPWR VGND sg13g2_decap_8
XFILLER_2_707 VPWR VGND sg13g2_fill_1
XFILLER_26_630 VPWR VGND sg13g2_decap_8
XFILLER_38_490 VPWR VGND sg13g2_decap_8
XFILLER_45_427 VPWR VGND sg13g2_decap_8
XFILLER_13_324 VPWR VGND sg13g2_decap_8
XFILLER_14_803 VPWR VGND sg13g2_fill_1
XFILLER_15_30 VPWR VGND sg13g2_decap_8
XFILLER_25_184 VPWR VGND sg13g2_decap_8
XFILLER_40_176 VPWR VGND sg13g2_decap_8
XFILLER_41_655 VPWR VGND sg13g2_fill_2
XFILLER_31_51 VPWR VGND sg13g2_decap_8
XFILLER_5_501 VPWR VGND sg13g2_decap_8
XFILLER_0_294 VPWR VGND sg13g2_decap_8
XFILLER_48_210 VPWR VGND sg13g2_decap_8
XFILLER_16_151 VPWR VGND sg13g2_decap_8
XFILLER_17_652 VPWR VGND sg13g2_decap_8
XFILLER_36_427 VPWR VGND sg13g2_decap_8
XFILLER_44_493 VPWR VGND sg13g2_decap_8
XFILLER_48_287 VPWR VGND sg13g2_decap_8
XFILLER_31_121 VPWR VGND sg13g2_decap_8
XFILLER_31_198 VPWR VGND sg13g2_decap_8
XFILLER_32_655 VPWR VGND sg13g2_decap_8
XFILLER_32_699 VPWR VGND sg13g2_fill_2
X_0506_ _0074_ _0289_ _0290_ net40 _0203_ VPWR VGND sg13g2_a22oi_1
XFILLER_27_405 VPWR VGND sg13g2_decap_8
XFILLER_39_243 VPWR VGND sg13g2_decap_8
XFILLER_22_154 VPWR VGND sg13g2_decap_8
XFILLER_23_666 VPWR VGND sg13g2_decap_8
XFILLER_10_349 VPWR VGND sg13g2_decap_8
XFILLER_2_515 VPWR VGND sg13g2_decap_8
XFILLER_6_309 VPWR VGND sg13g2_decap_8
Xclkbuf_4_13_0_clk clknet_0_clk clknet_4_13_0_clk VPWR VGND sg13g2_buf_8
XFILLER_14_611 VPWR VGND sg13g2_decap_4
XFILLER_18_427 VPWR VGND sg13g2_decap_8
XFILLER_26_84 VPWR VGND sg13g2_decap_8
XFILLER_45_224 VPWR VGND sg13g2_decap_8
XFILLER_13_121 VPWR VGND sg13g2_decap_8
XFILLER_13_198 VPWR VGND sg13g2_decap_8
XFILLER_41_496 VPWR VGND sg13g2_decap_8
XFILLER_42_72 VPWR VGND sg13g2_decap_8
XFILLER_9_158 VPWR VGND sg13g2_decap_8
XFILLER_3_11 VPWR VGND sg13g2_decap_8
XFILLER_5_375 VPWR VGND sg13g2_decap_8
XFILLER_47_7 VPWR VGND sg13g2_decap_8
XFILLER_36_224 VPWR VGND sg13g2_decap_8
XFILLER_3_88 VPWR VGND sg13g2_decap_8
XFILLER_49_585 VPWR VGND sg13g2_decap_8
XFILLER_32_452 VPWR VGND sg13g2_decap_8
XFILLER_20_647 VPWR VGND sg13g2_decap_8
X_0986_ net106 VGND VPWR _0146_ state\[18\] clknet_5_15__leaf_clk sg13g2_dfrbpq_1
XFILLER_47_28 VPWR VGND sg13g2_decap_8
Xfanout104 net108 net104 VPWR VGND sg13g2_buf_1
Xfanout115 net116 net115 VPWR VGND sg13g2_buf_1
XFILLER_15_408 VPWR VGND sg13g2_decap_8
XFILLER_27_202 VPWR VGND sg13g2_decap_8
XFILLER_27_279 VPWR VGND sg13g2_decap_8
XFILLER_28_725 VPWR VGND sg13g2_decap_8
XFILLER_28_758 VPWR VGND sg13g2_fill_1
XFILLER_28_769 VPWR VGND sg13g2_decap_8
XFILLER_10_146 VPWR VGND sg13g2_decap_8
XFILLER_12_20 VPWR VGND sg13g2_decap_8
XFILLER_23_463 VPWR VGND sg13g2_decap_8
XFILLER_42_238 VPWR VGND sg13g2_decap_8
XFILLER_6_106 VPWR VGND sg13g2_decap_8
XFILLER_12_97 VPWR VGND sg13g2_decap_8
XFILLER_2_312 VPWR VGND sg13g2_decap_8
XFILLER_18_224 VPWR VGND sg13g2_decap_8
XFILLER_19_725 VPWR VGND sg13g2_fill_2
XFILLER_2_389 VPWR VGND sg13g2_decap_8
XFILLER_46_511 VPWR VGND sg13g2_decap_8
XFILLER_33_249 VPWR VGND sg13g2_decap_8
XFILLER_46_588 VPWR VGND sg13g2_decap_8
XFILLER_14_485 VPWR VGND sg13g2_decap_8
XFILLER_41_293 VPWR VGND sg13g2_decap_8
X_0840_ VPWR _0051_ state\[27\] VGND sg13g2_inv_1
X_0771_ _0412_ VPWR _0179_ VGND net90 _0010_ sg13g2_o21ai_1
XFILLER_6_662 VPWR VGND sg13g2_fill_1
XFILLER_5_172 VPWR VGND sg13g2_decap_8
XFILLER_18_780 VPWR VGND sg13g2_fill_2
XFILLER_37_511 VPWR VGND sg13g2_decap_8
XFILLER_37_588 VPWR VGND sg13g2_decap_8
XFILLER_49_382 VPWR VGND sg13g2_decap_8
XFILLER_20_444 VPWR VGND sg13g2_decap_8
XFILLER_24_238 VPWR VGND sg13g2_decap_8
XFILLER_0_805 VPWR VGND sg13g2_decap_8
XFILLER_3_109 VPWR VGND sg13g2_decap_8
X_0969_ net100 VGND VPWR _0129_ state\[1\] clknet_5_3__leaf_clk sg13g2_dfrbpq_1
XFILLER_28_522 VPWR VGND sg13g2_decap_8
XFILLER_47_308 VPWR VGND sg13g2_decap_8
XFILLER_15_205 VPWR VGND sg13g2_decap_8
XFILLER_28_599 VPWR VGND sg13g2_decap_8
XFILLER_43_525 VPWR VGND sg13g2_decap_8
XFILLER_11_466 VPWR VGND sg13g2_decap_8
XFILLER_23_260 VPWR VGND sg13g2_decap_8
XFILLER_23_30 VPWR VGND sg13g2_fill_1
XFILLER_23_85 VPWR VGND sg13g2_decap_8
XFILLER_7_448 VPWR VGND sg13g2_decap_8
XFILLER_2_186 VPWR VGND sg13g2_decap_8
XFILLER_0_56 VPWR VGND sg13g2_decap_8
XFILLER_19_522 VPWR VGND sg13g2_decap_8
XFILLER_19_599 VPWR VGND sg13g2_decap_8
XFILLER_34_525 VPWR VGND sg13g2_decap_8
XFILLER_38_308 VPWR VGND sg13g2_decap_8
XFILLER_46_385 VPWR VGND sg13g2_decap_8
XFILLER_47_820 VPWR VGND sg13g2_fill_2
XFILLER_14_282 VPWR VGND sg13g2_decap_8
XFILLER_9_32 VPWR VGND sg13g2_decap_8
X_0823_ VPWR _0211_ daisychain\[18\] VGND sg13g2_inv_1
X_0754_ _0361_ VPWR _0162_ VGND net88 _0022_ sg13g2_o21ai_1
X_0685_ VGND VPWR net30 daisychain\[54\] _0425_ net48 sg13g2_a21oi_1
XFILLER_6_470 VPWR VGND sg13g2_decap_8
XFILLER_36_0 VPWR VGND sg13g2_decap_8
XFILLER_25_558 VPWR VGND sg13g2_decap_8
XFILLER_37_385 VPWR VGND sg13g2_decap_8
XFILLER_20_241 VPWR VGND sg13g2_decap_8
XFILLER_21_720 VPWR VGND sg13g2_decap_4
XFILLER_0_679 VPWR VGND sg13g2_decap_8
XFILLER_18_63 VPWR VGND sg13g2_decap_8
XFILLER_47_105 VPWR VGND sg13g2_decap_8
XFILLER_28_396 VPWR VGND sg13g2_decap_8
XFILLER_31_506 VPWR VGND sg13g2_decap_8
XFILLER_34_84 VPWR VGND sg13g2_decap_8
XFILLER_43_355 VPWR VGND sg13g2_decap_8
XFILLER_11_263 VPWR VGND sg13g2_decap_8
XFILLER_7_245 VPWR VGND sg13g2_decap_8
XFILLER_38_105 VPWR VGND sg13g2_decap_8
XFILLER_3_473 VPWR VGND sg13g2_decap_8
X_0470_ _0065_ _0262_ _0263_ net54 _0194_ VPWR VGND sg13g2_a22oi_1
XFILLER_19_396 VPWR VGND sg13g2_decap_8
XFILLER_34_322 VPWR VGND sg13g2_decap_8
XFILLER_46_182 VPWR VGND sg13g2_decap_8
X_1022_ net111 VGND VPWR _0182_ state\[54\] clknet_5_30__leaf_clk sg13g2_dfrbpq_1
XFILLER_22_539 VPWR VGND sg13g2_decap_8
XFILLER_30_550 VPWR VGND sg13g2_decap_8
XFILLER_34_399 VPWR VGND sg13g2_decap_8
X_0806_ VPWR _0033_ state\[10\] VGND sg13g2_inv_1
X_0737_ _0310_ VPWR _0145_ VGND net84 _0040_ sg13g2_o21ai_1
X_0668_ _0244_ net67 _0411_ _0412_ VPWR VGND sg13g2_a21o_1
XFILLER_38_650 VPWR VGND sg13g2_fill_2
X_0599_ net88 VPWR _0360_ VGND net67 state\[34\] sg13g2_o21ai_1
XFILLER_13_506 VPWR VGND sg13g2_decap_8
XFILLER_25_366 VPWR VGND sg13g2_decap_8
XFILLER_37_182 VPWR VGND sg13g2_decap_8
XFILLER_38_694 VPWR VGND sg13g2_decap_8
XFILLER_40_358 VPWR VGND sg13g2_decap_8
XFILLER_20_20 VPWR VGND sg13g2_fill_1
XFILLER_20_31 VPWR VGND sg13g2_decap_8
XFILLER_21_561 VPWR VGND sg13g2_decap_8
XFILLER_0_476 VPWR VGND sg13g2_decap_8
XFILLER_29_62 VPWR VGND sg13g2_decap_8
XFILLER_16_333 VPWR VGND sg13g2_decap_8
XFILLER_28_193 VPWR VGND sg13g2_decap_8
XFILLER_29_650 VPWR VGND sg13g2_decap_8
XFILLER_35_119 VPWR VGND sg13g2_decap_8
XFILLER_36_609 VPWR VGND sg13g2_decap_8
XFILLER_43_130 VPWR VGND sg13g2_decap_8
XFILLER_48_469 VPWR VGND sg13g2_decap_8
XFILLER_12_594 VPWR VGND sg13g2_decap_8
XFILLER_31_303 VPWR VGND sg13g2_decap_8
XFILLER_8_510 VPWR VGND sg13g2_decap_8
XANTENNA_4 VPWR VGND digitalen.g\[3\].u.OUTP sg13g2_antennanp
XFILLER_3_270 VPWR VGND sg13g2_decap_8
X_0522_ _0078_ _0301_ _0302_ net45 _0207_ VPWR VGND sg13g2_a22oi_1
XFILLER_8_587 VPWR VGND sg13g2_fill_1
XFILLER_6_99 VPWR VGND sg13g2_decap_8
XFILLER_6_11 VPWR VGND sg13g2_decap_8
XFILLER_26_119 VPWR VGND sg13g2_decap_8
X_0453_ VPWR _0252_ daisychain\[59\] VGND sg13g2_inv_1
XFILLER_19_193 VPWR VGND sg13g2_decap_8
XFILLER_22_336 VPWR VGND sg13g2_decap_8
XFILLER_23_815 VPWR VGND sg13g2_decap_8
XFILLER_34_196 VPWR VGND sg13g2_decap_8
X_1005_ net109 VGND VPWR _0165_ state\[37\] clknet_5_28__leaf_clk sg13g2_dfrbpq_1
XFILLER_18_609 VPWR VGND sg13g2_decap_8
XFILLER_45_406 VPWR VGND sg13g2_decap_8
XFILLER_13_303 VPWR VGND sg13g2_decap_8
XFILLER_15_86 VPWR VGND sg13g2_decap_8
XFILLER_25_163 VPWR VGND sg13g2_decap_8
XFILLER_26_686 VPWR VGND sg13g2_decap_8
XFILLER_40_155 VPWR VGND sg13g2_decap_8
XFILLER_31_30 VPWR VGND sg13g2_decap_8
XFILLER_0_273 VPWR VGND sg13g2_decap_8
XFILLER_36_406 VPWR VGND sg13g2_decap_8
XFILLER_49_778 VPWR VGND sg13g2_decap_8
XFILLER_49_767 VPWR VGND sg13g2_fill_1
XFILLER_49_734 VPWR VGND sg13g2_decap_8
XFILLER_49_712 VPWR VGND sg13g2_decap_8
XFILLER_48_266 VPWR VGND sg13g2_decap_8
XFILLER_16_130 VPWR VGND sg13g2_decap_8
XFILLER_17_631 VPWR VGND sg13g2_decap_8
XFILLER_31_100 VPWR VGND sg13g2_decap_8
XFILLER_32_634 VPWR VGND sg13g2_decap_8
XFILLER_44_450 VPWR VGND sg13g2_decap_8
XFILLER_44_472 VPWR VGND sg13g2_decap_8
XFILLER_12_391 VPWR VGND sg13g2_decap_8
XFILLER_31_177 VPWR VGND sg13g2_decap_8
XFILLER_8_384 VPWR VGND sg13g2_decap_8
X_0505_ VGND VPWR net26 daisychain\[9\] _0290_ net40 sg13g2_a21oi_1
.ends
